* Extracted by KLayout with GF180MCU LVS runset on : 24/07/2026 22:33

.SUBCKT strongarm
X$1 VOUT2 VDD CK VDD pfet$1
X$2 VSS VSS CK VSS nfet
X$3 VSS VDD CK VDD pfet$1
X$4 VOUT1 VDD CK VDD pfet$1
X$5 VSS VDD CK VDD pfet$1
X$6 VSS VSS VSS VSS VSS VIN1 VIN1 VIN1 VIN1 VSS nfet$4
X$7 VSS VSS VSS VSS VSS VIN2 VIN2 VIN2 VIN2 VSS nfet$4
X$8 VOUT2 VDD VOUT1 VDD pfet
X$9 VOUT1 VDD VOUT2 VDD pfet
X$10 VOUT1 VSS VOUT2 VSS nfet
X$11 VOUT2 VSS VOUT1 VSS nfet
.ENDS strongarm

.SUBCKT pfet$1 \$1 \$2 \$3 \$4
M$1 \$2 \$3 \$1 \$4 pfet_03v3 L=0.28U W=5U AS=3.25P AD=3.25P PS=11.3U PD=11.3U
.ENDS pfet$1

.SUBCKT pfet \$1 \$2 \$3 \$4
M$1 \$2 \$3 \$1 \$4 pfet_03v3 L=0.28U W=0.42U AS=0.2822P AD=0.2822P PS=2.18U
+ PD=2.18U
.ENDS pfet

.SUBCKT nfet \$1 \$2 \$3 \$5
M$1 \$2 \$3 \$1 \$5 nfet_03v3 L=0.28U W=2U AS=1.22P AD=1.22P PS=5.22U PD=5.22U
.ENDS nfet

.SUBCKT nfet$4 \$1 \$2 \$3 \$4 \$5 \$6 \$7 \$8 \$9 \$11
M$1 \$3 \$6 \$1 \$11 nfet_03v3 L=1U W=2U AS=1.22P AD=0.52P PS=5.22U PD=2.52U
M$2 \$4 \$8 \$3 \$11 nfet_03v3 L=1U W=2U AS=0.52P AD=0.52P PS=2.52U PD=2.52U
M$3 \$5 \$7 \$4 \$11 nfet_03v3 L=1U W=2U AS=0.52P AD=0.52P PS=2.52U PD=2.52U
M$4 \$2 \$9 \$5 \$11 nfet_03v3 L=1U W=2U AS=0.52P AD=1.22P PS=2.52U PD=5.22U
.ENDS nfet$4
