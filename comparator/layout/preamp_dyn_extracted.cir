* Extracted by KLayout with GF180MCU LVS runset on : 27/07/2026 21:17

.SUBCKT preamp_dyn CK DIP1 DIP2 VIN1 VIN2 VDD VSS
M$1 DIP2 VIN2 \$3 VSS nfet_03v3 L=1U W=64U AS=18.04P AD=18.04P PS=77.02U
+ PD=77.02U
M$17 DIP1 VIN1 \$3 VSS nfet_03v3 L=1U W=64U AS=18.04P AD=18.04P PS=77.02U
+ PD=77.02U
M$33 VDD CK DIP2 VDD pfet_03v3 L=0.3U W=3U AS=1.95P AD=1.95P PS=7.3U PD=7.3U
M$34 VDD CK DIP1 VDD pfet_03v3 L=0.3U W=3U AS=1.95P AD=1.95P PS=7.3U PD=7.3U
M$35 VSS CK \$3 VSS nfet_03v3 L=0.4U W=10U AS=3.3P AD=3.3P PS=15.3U PD=15.3U
.ENDS preamp_dyn
