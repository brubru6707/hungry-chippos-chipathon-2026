* Extracted by KLayout with GF180MCU LVS runset on : 10/07/2026 21:58

.SUBCKT strongarm CK VIN1 VIN2 VOUT1 VOUT2 VDD VSS
M$1 VDD VOUT2 VOUT1 VDD pfet_03v3 L=0.28U W=0.42U AS=0.2822P AD=0.2822P
+ PS=2.18U PD=2.18U
M$2 VDD CK \$4 VDD pfet_03v3 L=0.28U W=0.42U AS=0.2822P AD=0.2822P PS=2.18U
+ PD=2.18U
M$3 VDD CK \$5 VDD pfet_03v3 L=0.28U W=0.42U AS=0.2822P AD=0.2822P PS=2.18U
+ PD=2.18U
M$4 VDD CK VOUT2 VDD pfet_03v3 L=0.28U W=0.42U AS=0.2822P AD=0.2822P PS=2.18U
+ PD=2.18U
M$5 VDD VOUT1 VOUT2 VDD pfet_03v3 L=0.28U W=0.42U AS=0.2822P AD=0.2822P
+ PS=2.18U PD=2.18U
M$6 VOUT1 CK VDD VDD pfet_03v3 L=0.28U W=0.42U AS=0.2822P AD=0.2822P PS=2.18U
+ PD=2.18U
M$7 \$3 CK VSS VSS nfet_03v3 L=0.28U W=2U AS=1.22P AD=1.22P PS=5.22U PD=5.22U
M$8 \$5 VIN2 \$3 VSS nfet_03v3 L=0.28U W=2U AS=1.22P AD=1.22P PS=5.22U PD=5.22U
M$9 \$3 VIN1 \$4 VSS nfet_03v3 L=0.28U W=2U AS=1.22P AD=1.22P PS=5.22U PD=5.22U
M$10 VOUT2 VOUT1 \$5 VSS nfet_03v3 L=0.28U W=2U AS=1.22P AD=1.22P PS=5.22U
+ PD=5.22U
M$11 VOUT1 VOUT2 \$4 VSS nfet_03v3 L=0.28U W=2U AS=1.22P AD=1.22P PS=5.22U
+ PD=5.22U
.ENDS strongarm
