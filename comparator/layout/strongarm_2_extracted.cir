* Extracted by KLayout with GF180MCU LVS runset on : 28/07/2026 16:45

.SUBCKT strongarm_2 CK VIN1 VIN2 VOUT2 VOUT1 VDD VSS
M$1 VDD CK VOUT2 VDD pfet_03v3 L=0.28U W=5U AS=3.25P AD=3.25P PS=11.3U PD=11.3U
M$2 VDD CK \$6 VDD pfet_03v3 L=0.28U W=5U AS=3.25P AD=3.25P PS=11.3U PD=11.3U
M$3 VDD CK VOUT1 VDD pfet_03v3 L=0.28U W=5U AS=3.25P AD=3.25P PS=11.3U PD=11.3U
M$4 VDD CK \$5 VDD pfet_03v3 L=0.28U W=5U AS=3.25P AD=3.25P PS=11.3U PD=11.3U
M$5 VDD VOUT1 VOUT2 VDD pfet_03v3 L=0.28U W=0.42U AS=0.2822P AD=0.2822P
+ PS=2.18U PD=2.18U
M$6 VDD VOUT2 VOUT1 VDD pfet_03v3 L=0.28U W=0.42U AS=0.2822P AD=0.2822P
+ PS=2.18U PD=2.18U
M$7 VSS CK \$4 VSS nfet_03v3 L=0.28U W=2U AS=1.22P AD=1.22P PS=5.22U PD=5.22U
M$8 \$5 VOUT2 VOUT1 VSS nfet_03v3 L=0.28U W=2U AS=1.22P AD=1.22P PS=5.22U
+ PD=5.22U
M$9 \$6 VOUT1 VOUT2 VSS nfet_03v3 L=0.28U W=2U AS=1.22P AD=1.22P PS=5.22U
+ PD=5.22U
M$10 \$4 VIN2 \$6 VSS nfet_03v3 L=1U W=8U AS=2.78P AD=2.78P PS=12.78U PD=12.78U
M$14 \$4 VIN1 \$5 VSS nfet_03v3 L=1U W=8U AS=2.78P AD=2.78P PS=12.78U PD=12.78U
.ENDS strongarm_2
