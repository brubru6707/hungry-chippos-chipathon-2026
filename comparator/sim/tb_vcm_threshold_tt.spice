* StrongARM decision threshold vs common-mode, TT 3.3V 27C
* In-system load: identical inverter buffers + NOR SR latch (as adc_top).
.include /foss/pdks/gf180mcuD/libs.tech/ngspice/design.ngspice
.lib /foss/pdks/gf180mcuD/libs.tech/ngspice/sm141064.ngspice typical
.lib /foss/pdks/gf180mcuD/libs.tech/ngspice/smbb000149.ngspice typical

.include comp_char_cells.spice

VVDD VDD 0 3.3
VCK CK 0 PULSE(0 3.3 50n 1n 1n 49n 100n)
VIN1 vin1 0 PWL(0 0 1n 0.103200 99n 0.103200 101n 0.096800 199n 0.096800 201n 0.106400 299n 0.106400 301n 0.093600 399n 0.093600 401n 0.112900 499n 0.112900 501n 0.087100 599n 0.087100 601n 0.125700 699n 0.125700 701n 0.074300 799n 0.074300 801n 0.203200 899n 0.203200 901n 0.196800 999n 0.196800 1001n 0.206400 1099n 0.206400 1101n 0.193600 1199n 0.193600 1201n 0.212900 1299n 0.212900 1301n 0.187100 1399n 0.187100 1401n 0.225700 1499n 0.225700 1501n 0.174300 1599n 0.174300 1601n 0.303200 1699n 0.303200 1701n 0.296800 1799n 0.296800 1801n 0.306400 1899n 0.306400 1901n 0.293600 1999n 0.293600 2001n 0.312900 2099n 0.312900 2101n 0.287100 2199n 0.287100 2201n 0.325700 2299n 0.325700 2301n 0.274300 2399n 0.274300 2401n 0.403200 2499n 0.403200 2501n 0.396800 2599n 0.396800 2601n 0.406400 2699n 0.406400 2701n 0.393600 2799n 0.393600 2801n 0.412900 2899n 0.412900 2901n 0.387100 2999n 0.387100 3001n 0.425700 3099n 0.425700 3101n 0.374300 3199n 0.374300 3201n 0.503200 3299n 0.503200 3301n 0.496800 3399n 0.496800 3401n 0.506400 3499n 0.506400 3501n 0.493600 3599n 0.493600 3601n 0.512900 3699n 0.512900 3701n 0.487100 3799n 0.487100 3801n 0.525700 3899n 0.525700 3901n 0.474300 3999n 0.474300 4001n 0.603200 4099n 0.603200 4101n 0.596800 4199n 0.596800 4201n 0.606400 4299n 0.606400 4301n 0.593600 4399n 0.593600 4401n 0.612900 4499n 0.612900 4501n 0.587100 4599n 0.587100 4601n 0.625700 4699n 0.625700 4701n 0.574300 4799n 0.574300 4801n 0.703200 4899n 0.703200 4901n 0.696800 4999n 0.696800 5001n 0.706400 5099n 0.706400 5101n 0.693600 5199n 0.693600 5201n 0.712900 5299n 0.712900 5301n 0.687100 5399n 0.687100 5401n 0.725700 5499n 0.725700 5501n 0.674300 5599n 0.674300 5601n 0.803200 5699n 0.803200 5701n 0.796800 5799n 0.796800 5801n 0.806400 5899n 0.806400 5901n 0.793600 5999n 0.793600 6001n 0.812900 6099n 0.812900 6101n 0.787100 6199n 0.787100 6201n 0.825700 6299n 0.825700 6301n 0.774300 6399n 0.774300 6401n 0.903200 6499n 0.903200 6501n 0.896800 6599n 0.896800 6601n 0.906400 6699n 0.906400 6701n 0.893600 6799n 0.893600 6801n 0.912900 6899n 0.912900 6901n 0.887100 6999n 0.887100 7001n 0.925700 7099n 0.925700 7101n 0.874300 7199n 0.874300 7201n 1.003200 7299n 1.003200 7301n 0.996800 7399n 0.996800 7401n 1.006400 7499n 1.006400 7501n 0.993600 7599n 0.993600 7601n 1.012900 7699n 1.012900 7701n 0.987100 7799n 0.987100 7801n 1.025700 7899n 1.025700 7901n 0.974300 7999n 0.974300 8001n 1.103200 8099n 1.103200 8101n 1.096800 8199n 1.096800 8201n 1.106400 8299n 1.106400 8301n 1.093600 8399n 1.093600 8401n 1.112900 8499n 1.112900 8501n 1.087100 8599n 1.087100 8601n 1.125700 8699n 1.125700 8701n 1.074300 8799n 1.074300 8801n 1.203200 8899n 1.203200 8901n 1.196800 8999n 1.196800 9001n 1.206400 9099n 1.206400 9101n 1.193600 9199n 1.193600 9201n 1.212900 9299n 1.212900 9301n 1.187100 9399n 1.187100 9401n 1.225700 9499n 1.225700 9501n 1.174300 9599n 1.174300 9601n 1.303200 9699n 1.303200 9701n 1.296800 9799n 1.296800 9801n 1.306400 9899n 1.306400 9901n 1.293600 9999n 1.293600 10001n 1.312900 10099n 1.312900 10101n 1.287100 10199n 1.287100 10201n 1.325700 10299n 1.325700 10301n 1.274300 10399n 1.274300 10401n 1.403200 10499n 1.403200 10501n 1.396800 10599n 1.396800 10601n 1.406400 10699n 1.406400 10701n 1.393600 10799n 1.393600 10801n 1.412900 10899n 1.412900 10901n 1.387100 10999n 1.387100 11001n 1.425700 11099n 1.425700 11101n 1.374300 11199n 1.374300 11201n 1.503200 11299n 1.503200 11301n 1.496800 11399n 1.496800 11401n 1.506400 11499n 1.506400 11501n 1.493600 11599n 1.493600 11601n 1.512900 11699n 1.512900 11701n 1.487100 11799n 1.487100 11801n 1.525700 11899n 1.525700 11901n 1.474300 11999n 1.474300 12001n 1.603200 12099n 1.603200 12101n 1.596800 12199n 1.596800 12201n 1.606400 12299n 1.606400 12301n 1.593600 12399n 1.593600 12401n 1.612900 12499n 1.612900 12501n 1.587100 12599n 1.587100 12601n 1.625700 12699n 1.625700 12701n 1.574300 12799n 1.574300 12801n 1.703200 12899n 1.703200 12901n 1.696800 12999n 1.696800 13001n 1.706400 13099n 1.706400 13101n 1.693600 13199n 1.693600 13201n 1.712900 13299n 1.712900 13301n 1.687100 13399n 1.687100 13401n 1.725700 13499n 1.725700 13501n 1.674300 13599n 1.674300 13601n 1.803200 13699n 1.803200 13701n 1.796800 13799n 1.796800 13801n 1.806400 13899n 1.806400 13901n 1.793600 13999n 1.793600 14001n 1.812900 14099n 1.812900 14101n 1.787100 14199n 1.787100 14201n 1.825700 14299n 1.825700 14301n 1.774300 14399n 1.774300 14401n 1.903200 14499n 1.903200 14501n 1.896800 14599n 1.896800 14601n 1.906400 14699n 1.906400 14701n 1.893600 14799n 1.893600 14801n 1.912900 14899n 1.912900 14901n 1.887100 14999n 1.887100 15001n 1.925700 15099n 1.925700 15101n 1.874300 15199n 1.874300 15201n 2.003200 15299n 2.003200 15301n 1.996800 15399n 1.996800 15401n 2.006400 15499n 2.006400 15501n 1.993600 15599n 1.993600 15601n 2.012900 15699n 2.012900 15701n 1.987100 15799n 1.987100 15801n 2.025700 15899n 2.025700 15901n 1.974300 15999n 1.974300 16001n 2.103200 16099n 2.103200 16101n 2.096800 16199n 2.096800 16201n 2.106400 16299n 2.106400 16301n 2.093600 16399n 2.093600 16401n 2.112900 16499n 2.112900 16501n 2.087100 16599n 2.087100 16601n 2.125700 16699n 2.125700 16701n 2.074300 16799n 2.074300 16801n 2.203200 16899n 2.203200 16901n 2.196800 16999n 2.196800 17001n 2.206400 17099n 2.206400 17101n 2.193600 17199n 2.193600 17201n 2.212900 17299n 2.212900 17301n 2.187100 17399n 2.187100 17401n 2.225700 17499n 2.225700 17501n 2.174300 17599n 2.174300 17601n 2.303200 17699n 2.303200 17701n 2.296800 17799n 2.296800 17801n 2.306400 17899n 2.306400 17901n 2.293600 17999n 2.293600 18001n 2.312900 18099n 2.312900 18101n 2.287100 18199n 2.287100 18201n 2.325700 18299n 2.325700 18301n 2.274300 18399n 2.274300 18401n 2.403200 18499n 2.403200 18501n 2.396800 18599n 2.396800 18601n 2.406400 18699n 2.406400 18701n 2.393600 18799n 2.393600 18801n 2.412900 18899n 2.412900 18901n 2.387100 18999n 2.387100 19001n 2.425700 19099n 2.425700 19101n 2.374300 19199n 2.374300 19201n 2.503200 19299n 2.503200 19301n 2.496800 19399n 2.496800 19401n 2.506400 19499n 2.506400 19501n 2.493600 19599n 2.493600 19601n 2.512900 19699n 2.512900 19701n 2.487100 19799n 2.487100 19801n 2.525700 19899n 2.525700 19901n 2.474300 19999n 2.474300 20001n 2.603200 20099n 2.603200 20101n 2.596800 20199n 2.596800 20201n 2.606400 20299n 2.606400 20301n 2.593600 20399n 2.593600 20401n 2.612900 20499n 2.612900 20501n 2.587100 20599n 2.587100 20601n 2.625700 20699n 2.625700 20701n 2.574300 20799n 2.574300 20801n 2.703200 20899n 2.703200 20901n 2.696800 20999n 2.696800 21001n 2.706400 21099n 2.706400 21101n 2.693600 21199n 2.693600 21201n 2.712900 21299n 2.712900 21301n 2.687100 21399n 2.687100 21401n 2.725700 21499n 2.725700 21501n 2.674300 21599n 2.674300 21601n 2.803200 21699n 2.803200 21701n 2.796800 21799n 2.796800 21801n 2.806400 21899n 2.806400 21901n 2.793600 21999n 2.793600 22001n 2.812900 22099n 2.812900 22101n 2.787100 22199n 2.787100 22201n 2.825700 22299n 2.825700 22301n 2.774300 22399n 2.774300 22401n 2.903200 22499n 2.903200 22501n 2.896800 22599n 2.896800 22601n 2.906400 22699n 2.906400 22701n 2.893600 22799n 2.893600 22801n 2.912900 22899n 2.912900 22901n 2.887100 22999n 2.887100 23001n 2.925700 23099n 2.925700 23101n 2.874300 23199n 2.874300 23201n 3.003200 23299n 3.003200 23301n 2.996800 23399n 2.996800 23401n 3.006400 23499n 3.006400 23501n 2.993600 23599n 2.993600 23601n 3.012900 23699n 3.012900 23701n 2.987100 23799n 2.987100 23801n 3.025700 23899n 3.025700 23901n 2.974300 23999n 2.974300 24001n 3.103200 24099n 3.103200 24101n 3.096800 24199n 3.096800 24201n 3.106400 24299n 3.106400 24301n 3.093600 24399n 3.093600 24401n 3.112900 24499n 3.112900 24501n 3.087100 24599n 3.087100 24601n 3.125700 24699n 3.125700 24701n 3.074300 24799n 3.074300 24801n 3.203200 24899n 3.203200 24901n 3.196800 24999n 3.196800 25001n 3.206400 25099n 3.206400 25101n 3.193600 25199n 3.193600 25201n 3.212900 25299n 3.212900 25301n 3.187100 25399n 3.187100 25401n 3.225700 25499n 3.225700 25501n 3.174300 25599n 3.174300 25601n 3.303200 25699n 3.303200 25701n 3.296800 25799n 3.296800 25801n 3.306400 25899n 3.306400 25901n 3.293600 25999n 3.293600 26001n 3.312900 26099n 3.312900 26101n 3.287100 26199n 3.287100 26201n 3.325700 26299n 3.325700 26301n 3.274300 26399n 3.274300)
VIN2 vin2 0 PWL(0 0 1n 0.100000 99n 0.100000 101n 0.100000 199n 0.100000 201n 0.100000 299n 0.100000 301n 0.100000 399n 0.100000 401n 0.100000 499n 0.100000 501n 0.100000 599n 0.100000 601n 0.100000 699n 0.100000 701n 0.100000 799n 0.100000 801n 0.200000 899n 0.200000 901n 0.200000 999n 0.200000 1001n 0.200000 1099n 0.200000 1101n 0.200000 1199n 0.200000 1201n 0.200000 1299n 0.200000 1301n 0.200000 1399n 0.200000 1401n 0.200000 1499n 0.200000 1501n 0.200000 1599n 0.200000 1601n 0.300000 1699n 0.300000 1701n 0.300000 1799n 0.300000 1801n 0.300000 1899n 0.300000 1901n 0.300000 1999n 0.300000 2001n 0.300000 2099n 0.300000 2101n 0.300000 2199n 0.300000 2201n 0.300000 2299n 0.300000 2301n 0.300000 2399n 0.300000 2401n 0.400000 2499n 0.400000 2501n 0.400000 2599n 0.400000 2601n 0.400000 2699n 0.400000 2701n 0.400000 2799n 0.400000 2801n 0.400000 2899n 0.400000 2901n 0.400000 2999n 0.400000 3001n 0.400000 3099n 0.400000 3101n 0.400000 3199n 0.400000 3201n 0.500000 3299n 0.500000 3301n 0.500000 3399n 0.500000 3401n 0.500000 3499n 0.500000 3501n 0.500000 3599n 0.500000 3601n 0.500000 3699n 0.500000 3701n 0.500000 3799n 0.500000 3801n 0.500000 3899n 0.500000 3901n 0.500000 3999n 0.500000 4001n 0.600000 4099n 0.600000 4101n 0.600000 4199n 0.600000 4201n 0.600000 4299n 0.600000 4301n 0.600000 4399n 0.600000 4401n 0.600000 4499n 0.600000 4501n 0.600000 4599n 0.600000 4601n 0.600000 4699n 0.600000 4701n 0.600000 4799n 0.600000 4801n 0.700000 4899n 0.700000 4901n 0.700000 4999n 0.700000 5001n 0.700000 5099n 0.700000 5101n 0.700000 5199n 0.700000 5201n 0.700000 5299n 0.700000 5301n 0.700000 5399n 0.700000 5401n 0.700000 5499n 0.700000 5501n 0.700000 5599n 0.700000 5601n 0.800000 5699n 0.800000 5701n 0.800000 5799n 0.800000 5801n 0.800000 5899n 0.800000 5901n 0.800000 5999n 0.800000 6001n 0.800000 6099n 0.800000 6101n 0.800000 6199n 0.800000 6201n 0.800000 6299n 0.800000 6301n 0.800000 6399n 0.800000 6401n 0.900000 6499n 0.900000 6501n 0.900000 6599n 0.900000 6601n 0.900000 6699n 0.900000 6701n 0.900000 6799n 0.900000 6801n 0.900000 6899n 0.900000 6901n 0.900000 6999n 0.900000 7001n 0.900000 7099n 0.900000 7101n 0.900000 7199n 0.900000 7201n 1.000000 7299n 1.000000 7301n 1.000000 7399n 1.000000 7401n 1.000000 7499n 1.000000 7501n 1.000000 7599n 1.000000 7601n 1.000000 7699n 1.000000 7701n 1.000000 7799n 1.000000 7801n 1.000000 7899n 1.000000 7901n 1.000000 7999n 1.000000 8001n 1.100000 8099n 1.100000 8101n 1.100000 8199n 1.100000 8201n 1.100000 8299n 1.100000 8301n 1.100000 8399n 1.100000 8401n 1.100000 8499n 1.100000 8501n 1.100000 8599n 1.100000 8601n 1.100000 8699n 1.100000 8701n 1.100000 8799n 1.100000 8801n 1.200000 8899n 1.200000 8901n 1.200000 8999n 1.200000 9001n 1.200000 9099n 1.200000 9101n 1.200000 9199n 1.200000 9201n 1.200000 9299n 1.200000 9301n 1.200000 9399n 1.200000 9401n 1.200000 9499n 1.200000 9501n 1.200000 9599n 1.200000 9601n 1.300000 9699n 1.300000 9701n 1.300000 9799n 1.300000 9801n 1.300000 9899n 1.300000 9901n 1.300000 9999n 1.300000 10001n 1.300000 10099n 1.300000 10101n 1.300000 10199n 1.300000 10201n 1.300000 10299n 1.300000 10301n 1.300000 10399n 1.300000 10401n 1.400000 10499n 1.400000 10501n 1.400000 10599n 1.400000 10601n 1.400000 10699n 1.400000 10701n 1.400000 10799n 1.400000 10801n 1.400000 10899n 1.400000 10901n 1.400000 10999n 1.400000 11001n 1.400000 11099n 1.400000 11101n 1.400000 11199n 1.400000 11201n 1.500000 11299n 1.500000 11301n 1.500000 11399n 1.500000 11401n 1.500000 11499n 1.500000 11501n 1.500000 11599n 1.500000 11601n 1.500000 11699n 1.500000 11701n 1.500000 11799n 1.500000 11801n 1.500000 11899n 1.500000 11901n 1.500000 11999n 1.500000 12001n 1.600000 12099n 1.600000 12101n 1.600000 12199n 1.600000 12201n 1.600000 12299n 1.600000 12301n 1.600000 12399n 1.600000 12401n 1.600000 12499n 1.600000 12501n 1.600000 12599n 1.600000 12601n 1.600000 12699n 1.600000 12701n 1.600000 12799n 1.600000 12801n 1.700000 12899n 1.700000 12901n 1.700000 12999n 1.700000 13001n 1.700000 13099n 1.700000 13101n 1.700000 13199n 1.700000 13201n 1.700000 13299n 1.700000 13301n 1.700000 13399n 1.700000 13401n 1.700000 13499n 1.700000 13501n 1.700000 13599n 1.700000 13601n 1.800000 13699n 1.800000 13701n 1.800000 13799n 1.800000 13801n 1.800000 13899n 1.800000 13901n 1.800000 13999n 1.800000 14001n 1.800000 14099n 1.800000 14101n 1.800000 14199n 1.800000 14201n 1.800000 14299n 1.800000 14301n 1.800000 14399n 1.800000 14401n 1.900000 14499n 1.900000 14501n 1.900000 14599n 1.900000 14601n 1.900000 14699n 1.900000 14701n 1.900000 14799n 1.900000 14801n 1.900000 14899n 1.900000 14901n 1.900000 14999n 1.900000 15001n 1.900000 15099n 1.900000 15101n 1.900000 15199n 1.900000 15201n 2.000000 15299n 2.000000 15301n 2.000000 15399n 2.000000 15401n 2.000000 15499n 2.000000 15501n 2.000000 15599n 2.000000 15601n 2.000000 15699n 2.000000 15701n 2.000000 15799n 2.000000 15801n 2.000000 15899n 2.000000 15901n 2.000000 15999n 2.000000 16001n 2.100000 16099n 2.100000 16101n 2.100000 16199n 2.100000 16201n 2.100000 16299n 2.100000 16301n 2.100000 16399n 2.100000 16401n 2.100000 16499n 2.100000 16501n 2.100000 16599n 2.100000 16601n 2.100000 16699n 2.100000 16701n 2.100000 16799n 2.100000 16801n 2.200000 16899n 2.200000 16901n 2.200000 16999n 2.200000 17001n 2.200000 17099n 2.200000 17101n 2.200000 17199n 2.200000 17201n 2.200000 17299n 2.200000 17301n 2.200000 17399n 2.200000 17401n 2.200000 17499n 2.200000 17501n 2.200000 17599n 2.200000 17601n 2.300000 17699n 2.300000 17701n 2.300000 17799n 2.300000 17801n 2.300000 17899n 2.300000 17901n 2.300000 17999n 2.300000 18001n 2.300000 18099n 2.300000 18101n 2.300000 18199n 2.300000 18201n 2.300000 18299n 2.300000 18301n 2.300000 18399n 2.300000 18401n 2.400000 18499n 2.400000 18501n 2.400000 18599n 2.400000 18601n 2.400000 18699n 2.400000 18701n 2.400000 18799n 2.400000 18801n 2.400000 18899n 2.400000 18901n 2.400000 18999n 2.400000 19001n 2.400000 19099n 2.400000 19101n 2.400000 19199n 2.400000 19201n 2.500000 19299n 2.500000 19301n 2.500000 19399n 2.500000 19401n 2.500000 19499n 2.500000 19501n 2.500000 19599n 2.500000 19601n 2.500000 19699n 2.500000 19701n 2.500000 19799n 2.500000 19801n 2.500000 19899n 2.500000 19901n 2.500000 19999n 2.500000 20001n 2.600000 20099n 2.600000 20101n 2.600000 20199n 2.600000 20201n 2.600000 20299n 2.600000 20301n 2.600000 20399n 2.600000 20401n 2.600000 20499n 2.600000 20501n 2.600000 20599n 2.600000 20601n 2.600000 20699n 2.600000 20701n 2.600000 20799n 2.600000 20801n 2.700000 20899n 2.700000 20901n 2.700000 20999n 2.700000 21001n 2.700000 21099n 2.700000 21101n 2.700000 21199n 2.700000 21201n 2.700000 21299n 2.700000 21301n 2.700000 21399n 2.700000 21401n 2.700000 21499n 2.700000 21501n 2.700000 21599n 2.700000 21601n 2.800000 21699n 2.800000 21701n 2.800000 21799n 2.800000 21801n 2.800000 21899n 2.800000 21901n 2.800000 21999n 2.800000 22001n 2.800000 22099n 2.800000 22101n 2.800000 22199n 2.800000 22201n 2.800000 22299n 2.800000 22301n 2.800000 22399n 2.800000 22401n 2.900000 22499n 2.900000 22501n 2.900000 22599n 2.900000 22601n 2.900000 22699n 2.900000 22701n 2.900000 22799n 2.900000 22801n 2.900000 22899n 2.900000 22901n 2.900000 22999n 2.900000 23001n 2.900000 23099n 2.900000 23101n 2.900000 23199n 2.900000 23201n 3.000000 23299n 3.000000 23301n 3.000000 23399n 3.000000 23401n 3.000000 23499n 3.000000 23501n 3.000000 23599n 3.000000 23601n 3.000000 23699n 3.000000 23701n 3.000000 23799n 3.000000 23801n 3.000000 23899n 3.000000 23901n 3.000000 23999n 3.000000 24001n 3.100000 24099n 3.100000 24101n 3.100000 24199n 3.100000 24201n 3.100000 24299n 3.100000 24301n 3.100000 24399n 3.100000 24401n 3.100000 24499n 3.100000 24501n 3.100000 24599n 3.100000 24601n 3.100000 24699n 3.100000 24701n 3.100000 24799n 3.100000 24801n 3.200000 24899n 3.200000 24901n 3.200000 24999n 3.200000 25001n 3.200000 25099n 3.200000 25101n 3.200000 25199n 3.200000 25201n 3.200000 25299n 3.200000 25301n 3.200000 25399n 3.200000 25401n 3.200000 25499n 3.200000 25501n 3.200000 25599n 3.200000 25601n 3.300000 25699n 3.300000 25701n 3.300000 25799n 3.300000 25801n 3.300000 25899n 3.300000 25901n 3.300000 25999n 3.300000 26001n 3.300000 26099n 3.300000 26101n 3.300000 26199n 3.300000 26201n 3.300000 26299n 3.300000 26301n 3.300000 26399n 3.300000)

* strongarm VDD CK VOUT2 VOUT1 VIN1 VIN2 VSS
Xcmp VDD CK VOUT2 VOUT1 vin1 vin2 0 strongarm
Xib1 VDD VOUT1 V1B 0 inv
Xib2 VDD VOUT2 V2B 0 inv
Xnq VDD V2B QB Q 0 nor2
Xnqb VDD V1B Q QB 0 nor2

.tran 0.05n 26.4u

.meas tran q_0 FIND V(Q) AT=95n
.meas tran q_1 FIND V(Q) AT=195n
.meas tran q_2 FIND V(Q) AT=295n
.meas tran q_3 FIND V(Q) AT=395n
.meas tran q_4 FIND V(Q) AT=495n
.meas tran q_5 FIND V(Q) AT=595n
.meas tran q_6 FIND V(Q) AT=695n
.meas tran q_7 FIND V(Q) AT=795n
.meas tran q_8 FIND V(Q) AT=895n
.meas tran q_9 FIND V(Q) AT=995n
.meas tran q_10 FIND V(Q) AT=1095n
.meas tran q_11 FIND V(Q) AT=1195n
.meas tran q_12 FIND V(Q) AT=1295n
.meas tran q_13 FIND V(Q) AT=1395n
.meas tran q_14 FIND V(Q) AT=1495n
.meas tran q_15 FIND V(Q) AT=1595n
.meas tran q_16 FIND V(Q) AT=1695n
.meas tran q_17 FIND V(Q) AT=1795n
.meas tran q_18 FIND V(Q) AT=1895n
.meas tran q_19 FIND V(Q) AT=1995n
.meas tran q_20 FIND V(Q) AT=2095n
.meas tran q_21 FIND V(Q) AT=2195n
.meas tran q_22 FIND V(Q) AT=2295n
.meas tran q_23 FIND V(Q) AT=2395n
.meas tran q_24 FIND V(Q) AT=2495n
.meas tran q_25 FIND V(Q) AT=2595n
.meas tran q_26 FIND V(Q) AT=2695n
.meas tran q_27 FIND V(Q) AT=2795n
.meas tran q_28 FIND V(Q) AT=2895n
.meas tran q_29 FIND V(Q) AT=2995n
.meas tran q_30 FIND V(Q) AT=3095n
.meas tran q_31 FIND V(Q) AT=3195n
.meas tran q_32 FIND V(Q) AT=3295n
.meas tran q_33 FIND V(Q) AT=3395n
.meas tran q_34 FIND V(Q) AT=3495n
.meas tran q_35 FIND V(Q) AT=3595n
.meas tran q_36 FIND V(Q) AT=3695n
.meas tran q_37 FIND V(Q) AT=3795n
.meas tran q_38 FIND V(Q) AT=3895n
.meas tran q_39 FIND V(Q) AT=3995n
.meas tran q_40 FIND V(Q) AT=4095n
.meas tran q_41 FIND V(Q) AT=4195n
.meas tran q_42 FIND V(Q) AT=4295n
.meas tran q_43 FIND V(Q) AT=4395n
.meas tran q_44 FIND V(Q) AT=4495n
.meas tran q_45 FIND V(Q) AT=4595n
.meas tran q_46 FIND V(Q) AT=4695n
.meas tran q_47 FIND V(Q) AT=4795n
.meas tran q_48 FIND V(Q) AT=4895n
.meas tran q_49 FIND V(Q) AT=4995n
.meas tran q_50 FIND V(Q) AT=5095n
.meas tran q_51 FIND V(Q) AT=5195n
.meas tran q_52 FIND V(Q) AT=5295n
.meas tran q_53 FIND V(Q) AT=5395n
.meas tran q_54 FIND V(Q) AT=5495n
.meas tran q_55 FIND V(Q) AT=5595n
.meas tran q_56 FIND V(Q) AT=5695n
.meas tran q_57 FIND V(Q) AT=5795n
.meas tran q_58 FIND V(Q) AT=5895n
.meas tran q_59 FIND V(Q) AT=5995n
.meas tran q_60 FIND V(Q) AT=6095n
.meas tran q_61 FIND V(Q) AT=6195n
.meas tran q_62 FIND V(Q) AT=6295n
.meas tran q_63 FIND V(Q) AT=6395n
.meas tran q_64 FIND V(Q) AT=6495n
.meas tran q_65 FIND V(Q) AT=6595n
.meas tran q_66 FIND V(Q) AT=6695n
.meas tran q_67 FIND V(Q) AT=6795n
.meas tran q_68 FIND V(Q) AT=6895n
.meas tran q_69 FIND V(Q) AT=6995n
.meas tran q_70 FIND V(Q) AT=7095n
.meas tran q_71 FIND V(Q) AT=7195n
.meas tran q_72 FIND V(Q) AT=7295n
.meas tran q_73 FIND V(Q) AT=7395n
.meas tran q_74 FIND V(Q) AT=7495n
.meas tran q_75 FIND V(Q) AT=7595n
.meas tran q_76 FIND V(Q) AT=7695n
.meas tran q_77 FIND V(Q) AT=7795n
.meas tran q_78 FIND V(Q) AT=7895n
.meas tran q_79 FIND V(Q) AT=7995n
.meas tran q_80 FIND V(Q) AT=8095n
.meas tran q_81 FIND V(Q) AT=8195n
.meas tran q_82 FIND V(Q) AT=8295n
.meas tran q_83 FIND V(Q) AT=8395n
.meas tran q_84 FIND V(Q) AT=8495n
.meas tran q_85 FIND V(Q) AT=8595n
.meas tran q_86 FIND V(Q) AT=8695n
.meas tran q_87 FIND V(Q) AT=8795n
.meas tran q_88 FIND V(Q) AT=8895n
.meas tran q_89 FIND V(Q) AT=8995n
.meas tran q_90 FIND V(Q) AT=9095n
.meas tran q_91 FIND V(Q) AT=9195n
.meas tran q_92 FIND V(Q) AT=9295n
.meas tran q_93 FIND V(Q) AT=9395n
.meas tran q_94 FIND V(Q) AT=9495n
.meas tran q_95 FIND V(Q) AT=9595n
.meas tran q_96 FIND V(Q) AT=9695n
.meas tran q_97 FIND V(Q) AT=9795n
.meas tran q_98 FIND V(Q) AT=9895n
.meas tran q_99 FIND V(Q) AT=9995n
.meas tran q_100 FIND V(Q) AT=10095n
.meas tran q_101 FIND V(Q) AT=10195n
.meas tran q_102 FIND V(Q) AT=10295n
.meas tran q_103 FIND V(Q) AT=10395n
.meas tran q_104 FIND V(Q) AT=10495n
.meas tran q_105 FIND V(Q) AT=10595n
.meas tran q_106 FIND V(Q) AT=10695n
.meas tran q_107 FIND V(Q) AT=10795n
.meas tran q_108 FIND V(Q) AT=10895n
.meas tran q_109 FIND V(Q) AT=10995n
.meas tran q_110 FIND V(Q) AT=11095n
.meas tran q_111 FIND V(Q) AT=11195n
.meas tran q_112 FIND V(Q) AT=11295n
.meas tran q_113 FIND V(Q) AT=11395n
.meas tran q_114 FIND V(Q) AT=11495n
.meas tran q_115 FIND V(Q) AT=11595n
.meas tran q_116 FIND V(Q) AT=11695n
.meas tran q_117 FIND V(Q) AT=11795n
.meas tran q_118 FIND V(Q) AT=11895n
.meas tran q_119 FIND V(Q) AT=11995n
.meas tran q_120 FIND V(Q) AT=12095n
.meas tran q_121 FIND V(Q) AT=12195n
.meas tran q_122 FIND V(Q) AT=12295n
.meas tran q_123 FIND V(Q) AT=12395n
.meas tran q_124 FIND V(Q) AT=12495n
.meas tran q_125 FIND V(Q) AT=12595n
.meas tran q_126 FIND V(Q) AT=12695n
.meas tran q_127 FIND V(Q) AT=12795n
.meas tran q_128 FIND V(Q) AT=12895n
.meas tran q_129 FIND V(Q) AT=12995n
.meas tran q_130 FIND V(Q) AT=13095n
.meas tran q_131 FIND V(Q) AT=13195n
.meas tran q_132 FIND V(Q) AT=13295n
.meas tran q_133 FIND V(Q) AT=13395n
.meas tran q_134 FIND V(Q) AT=13495n
.meas tran q_135 FIND V(Q) AT=13595n
.meas tran q_136 FIND V(Q) AT=13695n
.meas tran q_137 FIND V(Q) AT=13795n
.meas tran q_138 FIND V(Q) AT=13895n
.meas tran q_139 FIND V(Q) AT=13995n
.meas tran q_140 FIND V(Q) AT=14095n
.meas tran q_141 FIND V(Q) AT=14195n
.meas tran q_142 FIND V(Q) AT=14295n
.meas tran q_143 FIND V(Q) AT=14395n
.meas tran q_144 FIND V(Q) AT=14495n
.meas tran q_145 FIND V(Q) AT=14595n
.meas tran q_146 FIND V(Q) AT=14695n
.meas tran q_147 FIND V(Q) AT=14795n
.meas tran q_148 FIND V(Q) AT=14895n
.meas tran q_149 FIND V(Q) AT=14995n
.meas tran q_150 FIND V(Q) AT=15095n
.meas tran q_151 FIND V(Q) AT=15195n
.meas tran q_152 FIND V(Q) AT=15295n
.meas tran q_153 FIND V(Q) AT=15395n
.meas tran q_154 FIND V(Q) AT=15495n
.meas tran q_155 FIND V(Q) AT=15595n
.meas tran q_156 FIND V(Q) AT=15695n
.meas tran q_157 FIND V(Q) AT=15795n
.meas tran q_158 FIND V(Q) AT=15895n
.meas tran q_159 FIND V(Q) AT=15995n
.meas tran q_160 FIND V(Q) AT=16095n
.meas tran q_161 FIND V(Q) AT=16195n
.meas tran q_162 FIND V(Q) AT=16295n
.meas tran q_163 FIND V(Q) AT=16395n
.meas tran q_164 FIND V(Q) AT=16495n
.meas tran q_165 FIND V(Q) AT=16595n
.meas tran q_166 FIND V(Q) AT=16695n
.meas tran q_167 FIND V(Q) AT=16795n
.meas tran q_168 FIND V(Q) AT=16895n
.meas tran q_169 FIND V(Q) AT=16995n
.meas tran q_170 FIND V(Q) AT=17095n
.meas tran q_171 FIND V(Q) AT=17195n
.meas tran q_172 FIND V(Q) AT=17295n
.meas tran q_173 FIND V(Q) AT=17395n
.meas tran q_174 FIND V(Q) AT=17495n
.meas tran q_175 FIND V(Q) AT=17595n
.meas tran q_176 FIND V(Q) AT=17695n
.meas tran q_177 FIND V(Q) AT=17795n
.meas tran q_178 FIND V(Q) AT=17895n
.meas tran q_179 FIND V(Q) AT=17995n
.meas tran q_180 FIND V(Q) AT=18095n
.meas tran q_181 FIND V(Q) AT=18195n
.meas tran q_182 FIND V(Q) AT=18295n
.meas tran q_183 FIND V(Q) AT=18395n
.meas tran q_184 FIND V(Q) AT=18495n
.meas tran q_185 FIND V(Q) AT=18595n
.meas tran q_186 FIND V(Q) AT=18695n
.meas tran q_187 FIND V(Q) AT=18795n
.meas tran q_188 FIND V(Q) AT=18895n
.meas tran q_189 FIND V(Q) AT=18995n
.meas tran q_190 FIND V(Q) AT=19095n
.meas tran q_191 FIND V(Q) AT=19195n
.meas tran q_192 FIND V(Q) AT=19295n
.meas tran q_193 FIND V(Q) AT=19395n
.meas tran q_194 FIND V(Q) AT=19495n
.meas tran q_195 FIND V(Q) AT=19595n
.meas tran q_196 FIND V(Q) AT=19695n
.meas tran q_197 FIND V(Q) AT=19795n
.meas tran q_198 FIND V(Q) AT=19895n
.meas tran q_199 FIND V(Q) AT=19995n
.meas tran q_200 FIND V(Q) AT=20095n
.meas tran q_201 FIND V(Q) AT=20195n
.meas tran q_202 FIND V(Q) AT=20295n
.meas tran q_203 FIND V(Q) AT=20395n
.meas tran q_204 FIND V(Q) AT=20495n
.meas tran q_205 FIND V(Q) AT=20595n
.meas tran q_206 FIND V(Q) AT=20695n
.meas tran q_207 FIND V(Q) AT=20795n
.meas tran q_208 FIND V(Q) AT=20895n
.meas tran q_209 FIND V(Q) AT=20995n
.meas tran q_210 FIND V(Q) AT=21095n
.meas tran q_211 FIND V(Q) AT=21195n
.meas tran q_212 FIND V(Q) AT=21295n
.meas tran q_213 FIND V(Q) AT=21395n
.meas tran q_214 FIND V(Q) AT=21495n
.meas tran q_215 FIND V(Q) AT=21595n
.meas tran q_216 FIND V(Q) AT=21695n
.meas tran q_217 FIND V(Q) AT=21795n
.meas tran q_218 FIND V(Q) AT=21895n
.meas tran q_219 FIND V(Q) AT=21995n
.meas tran q_220 FIND V(Q) AT=22095n
.meas tran q_221 FIND V(Q) AT=22195n
.meas tran q_222 FIND V(Q) AT=22295n
.meas tran q_223 FIND V(Q) AT=22395n
.meas tran q_224 FIND V(Q) AT=22495n
.meas tran q_225 FIND V(Q) AT=22595n
.meas tran q_226 FIND V(Q) AT=22695n
.meas tran q_227 FIND V(Q) AT=22795n
.meas tran q_228 FIND V(Q) AT=22895n
.meas tran q_229 FIND V(Q) AT=22995n
.meas tran q_230 FIND V(Q) AT=23095n
.meas tran q_231 FIND V(Q) AT=23195n
.meas tran q_232 FIND V(Q) AT=23295n
.meas tran q_233 FIND V(Q) AT=23395n
.meas tran q_234 FIND V(Q) AT=23495n
.meas tran q_235 FIND V(Q) AT=23595n
.meas tran q_236 FIND V(Q) AT=23695n
.meas tran q_237 FIND V(Q) AT=23795n
.meas tran q_238 FIND V(Q) AT=23895n
.meas tran q_239 FIND V(Q) AT=23995n
.meas tran q_240 FIND V(Q) AT=24095n
.meas tran q_241 FIND V(Q) AT=24195n
.meas tran q_242 FIND V(Q) AT=24295n
.meas tran q_243 FIND V(Q) AT=24395n
.meas tran q_244 FIND V(Q) AT=24495n
.meas tran q_245 FIND V(Q) AT=24595n
.meas tran q_246 FIND V(Q) AT=24695n
.meas tran q_247 FIND V(Q) AT=24795n
.meas tran q_248 FIND V(Q) AT=24895n
.meas tran q_249 FIND V(Q) AT=24995n
.meas tran q_250 FIND V(Q) AT=25095n
.meas tran q_251 FIND V(Q) AT=25195n
.meas tran q_252 FIND V(Q) AT=25295n
.meas tran q_253 FIND V(Q) AT=25395n
.meas tran q_254 FIND V(Q) AT=25495n
.meas tran q_255 FIND V(Q) AT=25595n
.meas tran q_256 FIND V(Q) AT=25695n
.meas tran q_257 FIND V(Q) AT=25795n
.meas tran q_258 FIND V(Q) AT=25895n
.meas tran q_259 FIND V(Q) AT=25995n
.meas tran q_260 FIND V(Q) AT=26095n
.meas tran q_261 FIND V(Q) AT=26195n
.meas tran q_262 FIND V(Q) AT=26295n
.meas tran q_263 FIND V(Q) AT=26395n
.control
set num_threads=2
run
.endc
.end
