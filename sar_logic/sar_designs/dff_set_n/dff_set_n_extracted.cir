* Extracted by KLayout with GF180MCU LVS runset on : 05/08/2026 22:05

.SUBCKT dff_set_n SET_N CLK VDD D Q VSS
X$1 VDD SET_N \$18 VSS inv
X$8 \$7 CLK VDD \$12 \$15 VSS tg
X$9 \$7 CLK VDD \$13 \$15 VSS tg
X$10 CLK \$7 VDD \$12 D VSS tg
X$15 VDD CLK \$7 VSS inv
X$17 CLK \$7 VDD \$13 \$36 VSS tg
X$18 \$12 \$18 \$21 VDD VSS nor2
X$19 \$13 \$18 \$14 VDD VSS nor2
X$20 VDD \$21 \$15 VSS inv
X$21 VDD \$14 \$36 VSS inv
X$22 VDD \$14 Q VSS inv
.ENDS dff_set_n

.SUBCKT nor2 A B Z VDD VSS
M$1 VSS A Z VSS nfet_03v3 L=0.28U W=0.5U AS=0.305P AD=0.305P PS=2.22U PD=2.22U
M$2 VSS B Z VSS nfet_03v3 L=0.28U W=0.5U AS=0.305P AD=0.305P PS=2.22U PD=2.22U
M$3 \$7 A VDD VDD pfet_03v3 L=0.28U W=2U AS=1.3P AD=1.3P PS=5.3U PD=5.3U
M$4 Z B \$7 VDD pfet_03v3 L=0.28U W=2U AS=1.3P AD=1.3P PS=5.3U PD=5.3U
.ENDS nor2

.SUBCKT tg CTRL_B CTRL VDD B A VSS
M$1 B CTRL A VSS nfet_03v3 L=0.28U W=0.5U AS=0.305P AD=0.305P PS=2.22U PD=2.22U
M$2 B CTRL_B A VDD pfet_03v3 L=0.28U W=1U AS=0.65P AD=0.65P PS=3.3U PD=3.3U
.ENDS tg

.SUBCKT inv VDD VIN VOUT VSS
M$1 VOUT VIN VSS VSS nfet_03v3 L=0.28U W=0.5U AS=0.305P AD=0.305P PS=2.22U
+ PD=2.22U
M$2 VOUT VIN VDD VDD pfet_03v3 L=0.28U W=1U AS=0.65P AD=0.65P PS=3.3U PD=3.3U
.ENDS inv
