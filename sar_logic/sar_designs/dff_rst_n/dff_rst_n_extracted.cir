* Extracted by KLayout with GF180MCU LVS runset on : 05/08/2026 22:06

.SUBCKT dff_rst_n VDD CLK RST_N D Q VSS
X$1 VDD \$12 RST_N \$27 VSS nand2
X$2 \$7 CLK VDD \$12 \$13 VSS tg
X$3 VDD CLK \$7 VSS inv
X$4 VDD \$14 RST_N \$15 VSS nand2
X$5 CLK \$7 VDD \$12 D VSS tg
X$6 \$7 CLK VDD \$14 \$13 VSS tg
X$7 CLK \$7 VDD \$14 \$34 VSS tg
X$8 VDD \$15 \$34 VSS inv
X$9 VDD \$15 Q VSS inv
X$10 VDD \$27 \$13 VSS inv
.ENDS dff_rst_n

.SUBCKT nand2 VDD A B Z VSS
M$1 \$7 A Z VSS nfet_03v3 L=0.28U W=1U AS=0.61P AD=0.61P PS=3.22U PD=3.22U
M$2 VSS B \$7 VSS nfet_03v3 L=0.28U W=1U AS=0.61P AD=0.61P PS=3.22U PD=3.22U
M$3 Z A VDD VDD pfet_03v3 L=0.28U W=1U AS=0.65P AD=0.65P PS=3.3U PD=3.3U
M$4 Z B VDD VDD pfet_03v3 L=0.28U W=1U AS=0.65P AD=0.65P PS=3.3U PD=3.3U
.ENDS nand2

.SUBCKT tg CTRL_B CTRL VDD B A VSS
M$1 B CTRL A VSS nfet_03v3 L=0.28U W=0.5U AS=0.305P AD=0.305P PS=2.22U PD=2.22U
M$2 B CTRL_B A VDD pfet_03v3 L=0.28U W=1U AS=0.65P AD=0.65P PS=3.3U PD=3.3U
.ENDS tg

.SUBCKT inv VDD VIN VOUT VSS
M$1 VOUT VIN VSS VSS nfet_03v3 L=0.28U W=0.5U AS=0.305P AD=0.305P PS=2.22U
+ PD=2.22U
M$2 VOUT VIN VDD VDD pfet_03v3 L=0.28U W=1U AS=0.65P AD=0.65P PS=3.3U PD=3.3U
.ENDS inv
