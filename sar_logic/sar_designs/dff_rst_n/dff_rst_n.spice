** sch_path: /foss/designs/dff_rst_n.sch
.subckt dff_rst_n VDD CLK D Q RST_N VSS
*.PININFO D:I CLK:I RST_N:I Q:O VDD:B VSS:B
x1 CLK VSS net5 net1 VDD net7 tg
x2 net7 VSS D net1 VDD CLK tg
x3 CLK VSS net5 net2 VDD net7 tg
x4 net7 VSS net6 net2 VDD CLK tg
x5 VDD net4 net1 RST_N VSS nand2
x6 VDD net3 net2 RST_N VSS nand2
x7 VDD net4 net5 VSS inv
x8 VDD net3 Q VSS inv
x9 VDD net3 net6 VSS inv
x10 VDD CLK net7 VSS inv
.ends

* expanding   symbol:  tg.sym # of pins=6
** sym_path: /foss/designs/tg.sym
** sch_path: /foss/designs/tg.sch
.subckt tg CTRL VSS A B VDD CTRL_B
*.PININFO VDD:B VSS:B A:B B:B CTRL_B:I CTRL:I
M1 A CTRL_B B VDD pfet_03v3 L=0.28u W=1u nf=1
M2 A CTRL B VSS nfet_03v3 L=0.28u W=0.5u nf=1
.ends

* expanding   symbol:  nand2.sym # of pins=5
** sym_path: /foss/designs/nand2.sym
** sch_path: /foss/designs/nand2.sch
.subckt nand2 VDD Z A B VSS
*.PININFO A:I B:I VSS:B VDD:B Z:O
M1 Z A VDD VDD pfet_03v3 L=0.28u W=1u nf=1
M2 Z B VDD VDD pfet_03v3 L=0.28u W=1u nf=1
M3 Z A net1 VSS nfet_03v3 L=0.28u W=1u nf=1
M4 net1 B VSS VSS nfet_03v3 L=0.28u W=1u nf=1
.ends

* expanding   symbol:  inv.sym # of pins=4
** sym_path: /foss/designs/inv.sym
** sch_path: /foss/designs/inv.sch
.subckt inv VDD vin vout VSS
*.PININFO vin:I vout:O VDD:B VSS:B
M1 vout vin VDD VDD pfet_03v3 L=0.28u W=1u nf=1
M2 vout vin VSS VSS nfet_03v3 L=0.28u W=0.5u nf=1
.ends
