** sch_path: /foss/designs/sar_logic.sch
.subckt sar_logic VDD VSS BIT_7 BIT_6 BIT_5 BIT_4 BIT_3 BIT_2 BIT_1 BIT_0 EOC RST_N CMP_OUT CLK
*.PININFO VDD:B VSS:B BIT_7:O BIT_6:O BIT_5:O BIT_4:O BIT_3:O BIT_2:O BIT_1:O BIT_0:O EOC:O RST_N:I CMP_OUT:I CLK:I
xS7 VDD CLK VSS net1 RST_N VSS dff_set_n
xS6 VDD CLK net1 net8 RST_N VSS dff_rst_n
xS5 VDD CLK net8 net2 RST_N VSS dff_rst_n
xS4 VDD CLK net2 net3 RST_N VSS dff_rst_n
xS3 VDD CLK net3 net4 RST_N VSS dff_rst_n
xS2 VDD CLK net4 net7 RST_N VSS dff_rst_n
xS1 VDD CLK net7 net5 RST_N VSS dff_rst_n
xS0 VDD CLK net5 net6 RST_N VSS dff_rst_n
xSEOC VDD CLK net6 EOC RST_N VSS dff_rst_n
xC7 VDD net8 CMP_OUT net9 RST_N VSS dff_rst_n
xC6 VDD net2 CMP_OUT net10 RST_N VSS dff_rst_n
xC5 VDD net3 CMP_OUT net11 RST_N VSS dff_rst_n
xC4 VDD net4 CMP_OUT net12 RST_N VSS dff_rst_n
xC3 VDD net7 CMP_OUT net13 RST_N VSS dff_rst_n
xC2 VDD net5 CMP_OUT net14 RST_N VSS dff_rst_n
xC1 VDD net6 CMP_OUT net15 RST_N VSS dff_rst_n
xC0 VDD EOC CMP_OUT net16 RST_N VSS dff_rst_n
x1 VDD net9 net1 net17 VSS nor2
x2 VDD net17 BIT_7 VSS inv
x3 VDD net10 net8 net18 VSS nor2
x4 VDD net18 BIT_6 VSS inv
x5 VDD net11 net2 net19 VSS nor2
x6 VDD net19 BIT_5 VSS inv
x7 VDD net12 net3 net20 VSS nor2
x8 VDD net20 BIT_4 VSS inv
x9 VDD net13 net4 net21 VSS nor2
x10 VDD net21 BIT_3 VSS inv
x11 VDD net14 net7 net22 VSS nor2
x12 VDD net22 BIT_2 VSS inv
x13 VDD net15 net5 net23 VSS nor2
x14 VDD net23 BIT_1 VSS inv
x15 VDD net16 net6 net24 VSS nor2
x16 VDD net24 BIT_0 VSS inv
.ends

* expanding   symbol:  dff_set_n.sym # of pins=6
** sym_path: /foss/designs/dff_set_n.sym
** sch_path: /foss/designs/dff_set_n.sch
.subckt dff_set_n VDD CLK D Q SET_N VSS
*.PININFO D:I CLK:I SET_N:I Q:O VDD:B VSS:B
x1 CLK VSS net2 net3 VDD net7 tg
x2 net7 VSS D net3 VDD CLK tg
x3 CLK VSS net2 net6 VDD net7 tg
x4 net7 VSS net5 net6 VDD CLK tg
x7 VDD net1 net2 VSS inv
x8 VDD net4 Q VSS inv
x9 VDD net4 net5 VSS inv
x10 VDD CLK net7 VSS inv
x5 VDD net3 net8 net1 VSS nor2
x6 VDD net6 net8 net4 VSS nor2
x11 VDD SET_N net8 VSS inv
.ends

* expanding   symbol:  dff_rst_n.sym # of pins=6
** sym_path: /foss/designs/dff_rst_n.sym
** sch_path: /foss/designs/dff_rst_n.sch
.subckt dff_rst_n VDD CLK D Q RST_N VSS
*.PININFO D:I CLK:I RST_N:I Q:O VDD:B VSS:B
x1 CLK VSS net5 net1 VDD net7 tg
x2 net7 VSS D net1 VDD CLK tg
x3 CLK VSS net5 net2 VDD net7 tg
x4 net7 VSS net6 net2 VDD CLK tg
x5 VDD net4 net1 RST_N VSS nand2
x6 VDD net3 net2 RST_N VSS nand2
x7 VDD net4 net5 VSS inv
x8 VDD net3 Q VSS inv
x9 VDD net3 net6 VSS inv
x10 VDD CLK net7 VSS inv
.ends

* expanding   symbol:  nor2.sym # of pins=5
** sym_path: /foss/designs/nor2.sym
** sch_path: /foss/designs/nor2.sch
.subckt nor2 VDD A B Z VSS
*.PININFO VSS:B VDD:B A:I B:I Z:O
M1 Z B net1 VDD pfet_03v3 L=0.28u W=2u nf=1
M2 net1 A VDD VDD pfet_03v3 L=0.28u W=2u nf=1
M3 Z A VSS VSS nfet_03v3 L=0.28u W=0.5u nf=1
M4 Z B VSS VSS nfet_03v3 L=0.28u W=0.5u nf=1
.ends

* expanding   symbol:  inv.sym # of pins=4
** sym_path: /foss/designs/inv.sym
** sch_path: /foss/designs/inv.sch
.subckt inv VDD vin vout VSS
*.PININFO vin:I vout:O VDD:B VSS:B
M1 vout vin VDD VDD pfet_03v3 L=0.28u W=1u nf=1
M2 vout vin VSS VSS nfet_03v3 L=0.28u W=0.5u nf=1
.ends

* expanding   symbol:  tg.sym # of pins=6
** sym_path: /foss/designs/tg.sym
** sch_path: /foss/designs/tg.sch
.subckt tg CTRL VSS A B VDD CTRL_B
*.PININFO VDD:B VSS:B A:B B:B CTRL_B:I CTRL:I
M1 A CTRL_B B VDD pfet_03v3 L=0.28u W=1u nf=1
M2 A CTRL B VSS nfet_03v3 L=0.28u W=0.5u nf=1
.ends

* expanding   symbol:  nand2.sym # of pins=5
** sym_path: /foss/designs/nand2.sym
** sch_path: /foss/designs/nand2.sch
.subckt nand2 VDD Z A B VSS
*.PININFO A:I B:I VSS:B VDD:B Z:O
M1 Z A VDD VDD pfet_03v3 L=0.28u W=1u nf=1
M2 Z B VDD VDD pfet_03v3 L=0.28u W=1u nf=1
M3 Z A net1 VSS nfet_03v3 L=0.28u W=1u nf=1
M4 net1 B VSS VSS nfet_03v3 L=0.28u W=1u nf=1
.ends
