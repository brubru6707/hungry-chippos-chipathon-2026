* Extracted by KLayout with GF180MCU LVS runset on : 05/08/2026 22:01

.SUBCKT tg CTRL_B CTRL VDD B A VSS
M$1 B CTRL A VSS nfet_03v3 L=0.28U W=0.5U AS=0.305P AD=0.305P PS=2.22U PD=2.22U
M$2 B CTRL_B A VDD pfet_03v3 L=0.28U W=1U AS=0.65P AD=0.65P PS=3.3U PD=3.3U
.ENDS tg
