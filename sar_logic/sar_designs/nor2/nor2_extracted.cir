* Extracted by KLayout with GF180MCU LVS runset on : 05/08/2026 22:04

.SUBCKT nor2 A B Z VDD VSS
M$1 VSS A Z VSS nfet_03v3 L=0.28U W=0.5U AS=0.305P AD=0.305P PS=2.22U PD=2.22U
M$2 VSS B Z VSS nfet_03v3 L=0.28U W=0.5U AS=0.305P AD=0.305P PS=2.22U PD=2.22U
M$3 \$7 A VDD VDD pfet_03v3 L=0.28U W=2U AS=1.3P AD=1.3P PS=5.3U PD=5.3U
M$4 Z B \$7 VDD pfet_03v3 L=0.28U W=2U AS=1.3P AD=1.3P PS=5.3U PD=5.3U
.ENDS nor2
