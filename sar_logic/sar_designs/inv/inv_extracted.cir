* Extracted by KLayout with GF180MCU LVS runset on : 05/08/2026 22:03

.SUBCKT inv VDD VIN VOUT VSS
M$1 VOUT VIN VSS VSS nfet_03v3 L=0.28U W=0.5U AS=0.305P AD=0.305P PS=2.22U
+ PD=2.22U
M$2 VOUT VIN VDD VDD pfet_03v3 L=0.28U W=1U AS=0.65P AD=0.65P PS=3.3U PD=3.3U
.ENDS inv
