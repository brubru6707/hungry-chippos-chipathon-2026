** sch_path: /foss/designs/sar_logic/sar_designs/tb_dff_set_n.sch
**.subckt tb_dff_set_n
VRST RST_N 0 PULSE(3.3 0 100n 1n 1n 100n 1000n)
VCLK CLK 0 PULSE(0 3.3 0 1n 1n 50n 100n)
VDATA D 0 PULSE(0 3.3 10n 1n 1n 120n 240n)
VVDD VDD 0 3.3
CLOAD Q 0 50f
x1 VDD CLK D Q RST_N 0 dff_set_n
**** begin user architecture code

.include /foss/pdks/gf180mcuD/libs.tech/ngspice/design.ngspice
.lib /foss/pdks/gf180mcuD/libs.tech/ngspice/sm141064.ngspice typical
.lib /foss/pdks/gf180mcuD/libs.tech/ngspice/smbb000149.ngspice typical

.control
  tran 1n 500n
  run
  plot V(CLK) V(RST_N) V(Q)
.endc

**** end user architecture code
**.ends

* expanding   symbol:  dff_set_n.sym # of pins=6
** sym_path: /foss/designs/sar_logic/sar_designs/dff_set_n.sym
** sch_path: /foss/designs/sar_logic/sar_designs/dff_set_n.sch
.subckt dff_set_n VDD CLK D Q RST_N VSS
*.ipin D
*.ipin CLK
*.ipin RST_N
*.opin Q
*.iopin VDD
*.iopin VSS
x1 CLK VSS net2 net3 VDD net7 tg
x2 net7 VSS D net3 VDD CLK tg
x3 CLK VSS net2 net6 VDD net7 tg
x4 net7 VSS net5 net6 VDD CLK tg
x7 VDD net1 net2 VSS inv
x8 VDD net4 Q VSS inv
x9 VDD net4 net5 VSS inv
x10 VDD CLK net7 VSS inv
x5 VDD net3 net8 net1 VSS nor2
x6 VDD net6 net8 net4 VSS nor2
x11 VDD RST_N net8 VSS inv
.ends

* expanding   symbol:  tg.sym # of pins=6
** sym_path: /foss/designs/sar_logic/sar_designs/tg.sym
** sch_path: /foss/designs/sar_logic/sar_designs/tg.sch
.subckt tg CTRL VSS A B VDD CTRL_B
*.iopin VDD
*.iopin VSS
*.iopin A
*.iopin B
*.ipin CTRL_B
*.ipin CTRL
XM1 A CTRL_B B VDD pfet_03v3 L=0.28u W=1u nf=1 ad='int((nf+1)/2) * W/nf * 0.18u' as='int((nf+2)/2) * W/nf * 0.18u' pd='2*int((nf+1)/2) * (W/nf + 0.18u)'
+ ps='2*int((nf+2)/2) * (W/nf + 0.18u)' nrd='0.18u / W' nrs='0.18u / W' sa=0 sb=0 sd=0
XM2 A CTRL B VSS nfet_03v3 L=0.28u W=0.5u nf=1 ad='int((nf+1)/2) * W/nf * 0.18u' as='int((nf+2)/2) * W/nf * 0.18u' pd='2*int((nf+1)/2) * (W/nf + 0.18u)'
+ ps='2*int((nf+2)/2) * (W/nf + 0.18u)' nrd='0.18u / W' nrs='0.18u / W' sa=0 sb=0 sd=0
.ends

* expanding   symbol:  inv.sym # of pins=4
** sym_path: /foss/designs/sar_logic/sar_designs/inv.sym
** sch_path: /foss/designs/sar_logic/sar_designs/inv.sch
.subckt inv VDD vin vout VSS
*.ipin vin
*.opin vout
*.iopin VDD
*.iopin VSS
XM1 vout vin VDD VDD pfet_03v3 L=0.28u W=1u nf=1 ad='int((nf+1)/2) * W/nf * 0.18u' as='int((nf+2)/2) * W/nf * 0.18u' pd='2*int((nf+1)/2) * (W/nf + 0.18u)'
+ ps='2*int((nf+2)/2) * (W/nf + 0.18u)' nrd='0.18u / W' nrs='0.18u / W' sa=0 sb=0 sd=0
XM2 vout vin VSS VSS nfet_03v3 L=0.28u W=0.5u nf=1 ad='int((nf+1)/2) * W/nf * 0.18u' as='int((nf+2)/2) * W/nf * 0.18u' pd='2*int((nf+1)/2) * (W/nf + 0.18u)'
+ ps='2*int((nf+2)/2) * (W/nf + 0.18u)' nrd='0.18u / W' nrs='0.18u / W' sa=0 sb=0 sd=0
.ends

* expanding   symbol:  nor2.sym # of pins=5
** sym_path: /foss/designs/sar_logic/sar_designs/nor2.sym
** sch_path: /foss/designs/sar_logic/sar_designs/nor2.sch
.subckt nor2 VDD A B Z VSS
*.iopin VSS
*.iopin VDD
*.ipin A
*.ipin B
*.opin Z
XM1 Z B net1 VDD pfet_03v3 L=0.28u W=2u nf=1 ad='int((nf+1)/2) * W/nf * 0.18u' as='int((nf+2)/2) * W/nf * 0.18u' pd='2*int((nf+1)/2) * (W/nf + 0.18u)'
+ ps='2*int((nf+2)/2) * (W/nf + 0.18u)' nrd='0.18u / W' nrs='0.18u / W' sa=0 sb=0 sd=0
XM2 net1 A VDD VDD pfet_03v3 L=0.28u W=2u nf=1 ad='int((nf+1)/2) * W/nf * 0.18u' as='int((nf+2)/2) * W/nf * 0.18u' pd='2*int((nf+1)/2) * (W/nf + 0.18u)'
+ ps='2*int((nf+2)/2) * (W/nf + 0.18u)' nrd='0.18u / W' nrs='0.18u / W' sa=0 sb=0 sd=0
XM3 Z A VSS VSS nfet_03v3 L=0.28u W=0.5u nf=1 ad='int((nf+1)/2) * W/nf * 0.18u' as='int((nf+2)/2) * W/nf * 0.18u' pd='2*int((nf+1)/2) * (W/nf + 0.18u)'
+ ps='2*int((nf+2)/2) * (W/nf + 0.18u)' nrd='0.18u / W' nrs='0.18u / W' sa=0 sb=0 sd=0
XM4 Z B VSS VSS nfet_03v3 L=0.28u W=0.5u nf=1 ad='int((nf+1)/2) * W/nf * 0.18u' as='int((nf+2)/2) * W/nf * 0.18u' pd='2*int((nf+1)/2) * (W/nf + 0.18u)'
+ ps='2*int((nf+2)/2) * (W/nf + 0.18u)' nrd='0.18u / W' nrs='0.18u / W' sa=0 sb=0 sd=0
.ends

.end
