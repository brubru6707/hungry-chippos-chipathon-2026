* Chip-level native-element LVS reference for adc_top (INT-8 / Gate 5).
* GENERATED by designs/scripts/gen_adc_chip_ref.py -- do not hand-edit.
* 377 DAC + 11 comparator + 458 SAR + 16 glue = 862 devices.

.subckt inv VDD vin vout VSS
M1 vout vin VDD VDD pfet_03v3 L=0.28u W=1u nf=1
M2 vout vin VSS VSS nfet_03v3 L=0.28u W=0.5u nf=1
.ends
.subckt tg CTRL VSS A B VDD CTRL_B
M1 A CTRL_B B VDD pfet_03v3 L=0.28u W=1u nf=1
M2 A CTRL B VSS nfet_03v3 L=0.28u W=0.5u nf=1
.ends
.subckt nand2 VDD Z A B VSS
M1 Z A VDD VDD pfet_03v3 L=0.28u W=1u nf=1
M2 Z B VDD VDD pfet_03v3 L=0.28u W=1u nf=1
M3 Z A net1 VSS nfet_03v3 L=0.28u W=1u nf=1
M4 net1 B VSS VSS nfet_03v3 L=0.28u W=1u nf=1
.ends
.subckt nor2 VDD A B Z VSS
M1 Z B net1 VDD pfet_03v3 L=0.28u W=2u nf=1
M2 net1 A VDD VDD pfet_03v3 L=0.28u W=2u nf=1
M3 Z A VSS VSS nfet_03v3 L=0.28u W=0.5u nf=1
M4 Z B VSS VSS nfet_03v3 L=0.28u W=0.5u nf=1
.ends
.subckt dff_set_n VDD CLK D Q RST_N VSS
x1 CLK VSS net2 net3 VDD net7 tg
x2 net7 VSS D net3 VDD CLK tg
x3 CLK VSS net2 net6 VDD net7 tg
x4 net7 VSS net5 net6 VDD CLK tg
x7 VDD net1 net2 VSS inv
x8 VDD net4 Q VSS inv
x9 VDD net4 net5 VSS inv
x10 VDD CLK net7 VSS inv
x5 VDD net3 net8 net1 VSS nor2
x6 VDD net6 net8 net4 VSS nor2
x11 VDD RST_N net8 VSS inv
.ends
.subckt dff_rst_n VDD CLK D Q RST_N VSS
x1 CLK VSS net4 net1 VDD net7 tg
x2 net7 VSS D net1 VDD CLK tg
x3 CLK VSS net4 net2 VDD net7 tg
x4 net7 VSS net6 net2 VDD CLK tg
x5 VDD net3 net1 RST_N VSS nand2
x6 VDD net5 net2 RST_N VSS nand2
x7 VDD net3 net4 VSS inv
x8 VDD net5 Q VSS inv
x9 VDD net5 net6 VSS inv
x10 VDD CLK net7 VSS inv
.ends
.subckt sar_logic VDD VSS BIT_7 BIT_6 BIT_5 BIT_4 BIT_3 BIT_2 BIT_1 BIT_0 EOC RST_N CMP_OUT CLK
XS7 VDD CLK VSS net1 RST_N VSS dff_set_n
XS6 VDD CLK net1 net8 RST_N VSS dff_rst_n
XS5 VDD CLK net8 net2 RST_N VSS dff_rst_n
XS4 VDD CLK net2 net3 RST_N VSS dff_rst_n
XS3 VDD CLK net3 net4 RST_N VSS dff_rst_n
XS2 VDD CLK net4 net7 RST_N VSS dff_rst_n
XS1 VDD CLK net7 net5 RST_N VSS dff_rst_n
XS0 VDD CLK net5 net6 RST_N VSS dff_rst_n
XSEOC VDD CLK net6 EOC RST_N VSS dff_rst_n
XC7 VDD net8 CMP_OUT net9 RST_N VSS dff_rst_n
XC6 VDD net2 CMP_OUT net10 RST_N VSS dff_rst_n
XC5 VDD net3 CMP_OUT net11 RST_N VSS dff_rst_n
XC4 VDD net4 CMP_OUT net12 RST_N VSS dff_rst_n
XC3 VDD net7 CMP_OUT net13 RST_N VSS dff_rst_n
XC2 VDD net5 CMP_OUT net14 RST_N VSS dff_rst_n
XC1 VDD net6 CMP_OUT net15 RST_N VSS dff_rst_n
XC0 VDD EOC CMP_OUT net16 RST_N VSS dff_rst_n
x1 VDD net9 net1 net17 VSS nor2
x2 VDD net17 BIT_7 VSS inv
x3 VDD net10 net8 net18 VSS nor2
x4 VDD net18 BIT_6 VSS inv
x5 VDD net11 net2 net19 VSS nor2
x6 VDD net19 BIT_5 VSS inv
x7 VDD net12 net3 net20 VSS nor2
x8 VDD net20 BIT_4 VSS inv
x9 VDD net13 net4 net21 VSS nor2
x10 VDD net21 BIT_3 VSS inv
x11 VDD net14 net7 net22 VSS nor2
x12 VDD net22 BIT_2 VSS inv
x13 VDD net15 net5 net23 VSS nor2
x14 VDD net23 BIT_1 VSS inv
x15 VDD net16 net6 net24 VSS nor2
x16 VDD net24 BIT_0 VSS inv
.ends
.subckt strongarm VDD CK VOUT2 VOUT1 VIN1 VIN2 VSS
M1 VOUT2 VOUT1 net1 VSS nfet_03v3 L=0.28u W=2u nf=1
M2 VOUT1 VOUT2 VDD VDD pfet_03v3 L=0.28u W=0.42u nf=1
M3 VOUT1 CK VDD VDD pfet_03v3 L=0.28u W=0.42u nf=1
M4 net3 CK VDD VDD pfet_03v3 L=0.28u W=0.42u nf=1
M5 net1 CK VDD VDD pfet_03v3 L=0.28u W=0.42u nf=1
M6 VOUT2 CK VDD VDD pfet_03v3 L=0.28u W=0.42u nf=1
M7 VOUT2 VOUT1 VDD VDD pfet_03v3 L=0.28u W=0.42u nf=1
M8 net1 VIN2 net2 VSS nfet_03v3 L=0.28u W=2u nf=1
M9 VOUT1 VOUT2 net3 VSS nfet_03v3 L=0.28u W=2u nf=1
M10 net3 VIN1 net2 VSS nfet_03v3 L=0.28u W=2u nf=1
M11 net2 CK VSS VSS nfet_03v3 L=0.28u W=2u nf=1
.ends
.subckt dac_top_floorplan VIN VDD SAMPLE B0 B1 B2 B3 B4 B5 B6 B7 DAC_TOP VSS
MNP0A B0NAND B0 VDD VDD pfet_03v3 L=0.3u W=1.7u nf=1
MNP0B B0NAND SAMPLE_N VDD VDD pfet_03v3 L=0.3u W=1.7u nf=1
MNN0B B0NAND SAMPLE_N NMID0 VSS nfet_03v3 L=0.3u W=1.7u nf=1
MNN0A NMID0 B0 VSS VSS nfet_03v3 L=0.3u W=1.7u nf=1
MDP0 RAIL0 B0NAND VDD VDD pfet_03v3 L=0.28u W=0.84u nf=1
MDN0 RAIL0 B0NAND VSS VSS nfet_03v3 L=0.28u W=0.42u nf=1
MNP1A B1NAND B1 VDD VDD pfet_03v3 L=0.3u W=1.7u nf=1
MNP1B B1NAND SAMPLE_N VDD VDD pfet_03v3 L=0.3u W=1.7u nf=1
MNN1B B1NAND SAMPLE_N NMID1 VSS nfet_03v3 L=0.3u W=1.7u nf=1
MNN1A NMID1 B1 VSS VSS nfet_03v3 L=0.3u W=1.7u nf=1
MDP1 RAIL1 B1NAND VDD VDD pfet_03v3 L=0.28u W=1.68u nf=1
MDN1 RAIL1 B1NAND VSS VSS nfet_03v3 L=0.28u W=0.84u nf=1
MNP2A B2NAND B2 VDD VDD pfet_03v3 L=0.3u W=1.7u nf=1
MNP2B B2NAND SAMPLE_N VDD VDD pfet_03v3 L=0.3u W=1.7u nf=1
MNN2B B2NAND SAMPLE_N NMID2 VSS nfet_03v3 L=0.3u W=1.7u nf=1
MNN2A NMID2 B2 VSS VSS nfet_03v3 L=0.3u W=1.7u nf=1
MDP2 RAIL2 B2NAND VDD VDD pfet_03v3 L=0.28u W=3.36u nf=1
MDN2 RAIL2 B2NAND VSS VSS nfet_03v3 L=0.28u W=1.68u nf=1
MNP3A B3NAND B3 VDD VDD pfet_03v3 L=0.3u W=1.7u nf=1
MNP3B B3NAND SAMPLE_N VDD VDD pfet_03v3 L=0.3u W=1.7u nf=1
MNN3B B3NAND SAMPLE_N NMID3 VSS nfet_03v3 L=0.3u W=1.7u nf=1
MNN3A NMID3 B3 VSS VSS nfet_03v3 L=0.3u W=1.7u nf=1
MDP3 RAIL3 B3NAND VDD VDD pfet_03v3 L=0.28u W=6.72u nf=1
MDN3 RAIL3 B3NAND VSS VSS nfet_03v3 L=0.28u W=3.36u nf=1
MNP4A B4NAND B4 VDD VDD pfet_03v3 L=0.3u W=1.7u nf=1
MNP4B B4NAND SAMPLE_N VDD VDD pfet_03v3 L=0.3u W=1.7u nf=1
MNN4B B4NAND SAMPLE_N NMID4 VSS nfet_03v3 L=0.3u W=1.7u nf=1
MNN4A NMID4 B4 VSS VSS nfet_03v3 L=0.3u W=1.7u nf=1
MDP4 RAIL4 B4NAND VDD VDD pfet_03v3 L=0.28u W=13.44u nf=1
MDN4 RAIL4 B4NAND VSS VSS nfet_03v3 L=0.28u W=6.72u nf=1
MNP5A B5NAND B5 VDD VDD pfet_03v3 L=0.3u W=1.7u nf=1
MNP5B B5NAND SAMPLE_N VDD VDD pfet_03v3 L=0.3u W=1.7u nf=1
MNN5B B5NAND SAMPLE_N NMID5 VSS nfet_03v3 L=0.3u W=1.7u nf=1
MNN5A NMID5 B5 VSS VSS nfet_03v3 L=0.3u W=1.7u nf=1
MDP5 RAIL5 B5NAND VDD VDD pfet_03v3 L=0.28u W=26.88u nf=1
MDN5 RAIL5 B5NAND VSS VSS nfet_03v3 L=0.28u W=13.44u nf=1
MNP6A B6NAND B6 VDD VDD pfet_03v3 L=0.3u W=1.7u nf=1
MNP6B B6NAND SAMPLE_N VDD VDD pfet_03v3 L=0.3u W=1.7u nf=1
MNN6B B6NAND SAMPLE_N NMID6 VSS nfet_03v3 L=0.3u W=1.7u nf=1
MNN6A NMID6 B6 VSS VSS nfet_03v3 L=0.3u W=1.7u nf=1
MDP6 RAIL6 B6NAND VDD VDD pfet_03v3 L=0.28u W=53.76u nf=1
MDN6 RAIL6 B6NAND VSS VSS nfet_03v3 L=0.28u W=26.88u nf=1
MNP7A B7NAND B7 VDD VDD pfet_03v3 L=0.3u W=1.7u nf=1
MNP7B B7NAND SAMPLE_N VDD VDD pfet_03v3 L=0.3u W=1.7u nf=1
MNN7B B7NAND SAMPLE_N NMID7 VSS nfet_03v3 L=0.3u W=1.7u nf=1
MNN7A NMID7 B7 VSS VSS nfet_03v3 L=0.3u W=1.7u nf=1
MDP7A RAIL7 B7NAND VDD VDD pfet_03v3 L=0.28u W=53.76u nf=1
MDP7B RAIL7 B7NAND VDD VDD pfet_03v3 L=0.28u W=53.76u nf=1
MDN7 RAIL7 B7NAND VSS VSS nfet_03v3 L=0.28u W=53.76u nf=1
C1 RAIL0 DAC_TOP cap_mim_2f0fF W=5e-6 L=5e-6 M=1
C2 RAIL1 DAC_TOP cap_mim_2f0fF W=5e-6 L=5e-6 M=1
C3 RAIL1 DAC_TOP cap_mim_2f0fF W=5e-6 L=5e-6 M=1
C4 RAIL2 DAC_TOP cap_mim_2f0fF W=5e-6 L=5e-6 M=1
C5 RAIL2 DAC_TOP cap_mim_2f0fF W=5e-6 L=5e-6 M=1
C6 RAIL2 DAC_TOP cap_mim_2f0fF W=5e-6 L=5e-6 M=1
C7 RAIL2 DAC_TOP cap_mim_2f0fF W=5e-6 L=5e-6 M=1
C8 RAIL3 DAC_TOP cap_mim_2f0fF W=5e-6 L=5e-6 M=1
C9 RAIL3 DAC_TOP cap_mim_2f0fF W=5e-6 L=5e-6 M=1
C10 RAIL3 DAC_TOP cap_mim_2f0fF W=5e-6 L=5e-6 M=1
C11 RAIL3 DAC_TOP cap_mim_2f0fF W=5e-6 L=5e-6 M=1
C12 RAIL3 DAC_TOP cap_mim_2f0fF W=5e-6 L=5e-6 M=1
C13 RAIL3 DAC_TOP cap_mim_2f0fF W=5e-6 L=5e-6 M=1
C14 RAIL3 DAC_TOP cap_mim_2f0fF W=5e-6 L=5e-6 M=1
C15 RAIL3 DAC_TOP cap_mim_2f0fF W=5e-6 L=5e-6 M=1
C16 RAIL4 DAC_TOP cap_mim_2f0fF W=5e-6 L=5e-6 M=1
C17 RAIL4 DAC_TOP cap_mim_2f0fF W=5e-6 L=5e-6 M=1
C18 RAIL4 DAC_TOP cap_mim_2f0fF W=5e-6 L=5e-6 M=1
C19 RAIL4 DAC_TOP cap_mim_2f0fF W=5e-6 L=5e-6 M=1
C20 RAIL4 DAC_TOP cap_mim_2f0fF W=5e-6 L=5e-6 M=1
C21 RAIL4 DAC_TOP cap_mim_2f0fF W=5e-6 L=5e-6 M=1
C22 RAIL4 DAC_TOP cap_mim_2f0fF W=5e-6 L=5e-6 M=1
C23 RAIL4 DAC_TOP cap_mim_2f0fF W=5e-6 L=5e-6 M=1
C24 RAIL4 DAC_TOP cap_mim_2f0fF W=5e-6 L=5e-6 M=1
C25 RAIL4 DAC_TOP cap_mim_2f0fF W=5e-6 L=5e-6 M=1
C26 RAIL4 DAC_TOP cap_mim_2f0fF W=5e-6 L=5e-6 M=1
C27 RAIL4 DAC_TOP cap_mim_2f0fF W=5e-6 L=5e-6 M=1
C28 RAIL4 DAC_TOP cap_mim_2f0fF W=5e-6 L=5e-6 M=1
C29 RAIL4 DAC_TOP cap_mim_2f0fF W=5e-6 L=5e-6 M=1
C30 RAIL4 DAC_TOP cap_mim_2f0fF W=5e-6 L=5e-6 M=1
C31 RAIL4 DAC_TOP cap_mim_2f0fF W=5e-6 L=5e-6 M=1
C32 RAIL5 DAC_TOP cap_mim_2f0fF W=5e-6 L=5e-6 M=1
C33 RAIL5 DAC_TOP cap_mim_2f0fF W=5e-6 L=5e-6 M=1
C34 RAIL5 DAC_TOP cap_mim_2f0fF W=5e-6 L=5e-6 M=1
C35 RAIL5 DAC_TOP cap_mim_2f0fF W=5e-6 L=5e-6 M=1
C36 RAIL5 DAC_TOP cap_mim_2f0fF W=5e-6 L=5e-6 M=1
C37 RAIL5 DAC_TOP cap_mim_2f0fF W=5e-6 L=5e-6 M=1
C38 RAIL5 DAC_TOP cap_mim_2f0fF W=5e-6 L=5e-6 M=1
C39 RAIL5 DAC_TOP cap_mim_2f0fF W=5e-6 L=5e-6 M=1
C40 RAIL5 DAC_TOP cap_mim_2f0fF W=5e-6 L=5e-6 M=1
C41 RAIL5 DAC_TOP cap_mim_2f0fF W=5e-6 L=5e-6 M=1
C42 RAIL5 DAC_TOP cap_mim_2f0fF W=5e-6 L=5e-6 M=1
C43 RAIL5 DAC_TOP cap_mim_2f0fF W=5e-6 L=5e-6 M=1
C44 RAIL5 DAC_TOP cap_mim_2f0fF W=5e-6 L=5e-6 M=1
C45 RAIL5 DAC_TOP cap_mim_2f0fF W=5e-6 L=5e-6 M=1
C46 RAIL5 DAC_TOP cap_mim_2f0fF W=5e-6 L=5e-6 M=1
C47 RAIL5 DAC_TOP cap_mim_2f0fF W=5e-6 L=5e-6 M=1
C48 RAIL5 DAC_TOP cap_mim_2f0fF W=5e-6 L=5e-6 M=1
C49 RAIL5 DAC_TOP cap_mim_2f0fF W=5e-6 L=5e-6 M=1
C50 RAIL5 DAC_TOP cap_mim_2f0fF W=5e-6 L=5e-6 M=1
C51 RAIL5 DAC_TOP cap_mim_2f0fF W=5e-6 L=5e-6 M=1
C52 RAIL5 DAC_TOP cap_mim_2f0fF W=5e-6 L=5e-6 M=1
C53 RAIL5 DAC_TOP cap_mim_2f0fF W=5e-6 L=5e-6 M=1
C54 RAIL5 DAC_TOP cap_mim_2f0fF W=5e-6 L=5e-6 M=1
C55 RAIL5 DAC_TOP cap_mim_2f0fF W=5e-6 L=5e-6 M=1
C56 RAIL5 DAC_TOP cap_mim_2f0fF W=5e-6 L=5e-6 M=1
C57 RAIL5 DAC_TOP cap_mim_2f0fF W=5e-6 L=5e-6 M=1
C58 RAIL5 DAC_TOP cap_mim_2f0fF W=5e-6 L=5e-6 M=1
C59 RAIL5 DAC_TOP cap_mim_2f0fF W=5e-6 L=5e-6 M=1
C60 RAIL5 DAC_TOP cap_mim_2f0fF W=5e-6 L=5e-6 M=1
C61 RAIL5 DAC_TOP cap_mim_2f0fF W=5e-6 L=5e-6 M=1
C62 RAIL5 DAC_TOP cap_mim_2f0fF W=5e-6 L=5e-6 M=1
C63 RAIL5 DAC_TOP cap_mim_2f0fF W=5e-6 L=5e-6 M=1
C64 RAIL6 DAC_TOP cap_mim_2f0fF W=5e-6 L=5e-6 M=1
C65 RAIL6 DAC_TOP cap_mim_2f0fF W=5e-6 L=5e-6 M=1
C66 RAIL6 DAC_TOP cap_mim_2f0fF W=5e-6 L=5e-6 M=1
C67 RAIL6 DAC_TOP cap_mim_2f0fF W=5e-6 L=5e-6 M=1
C68 RAIL6 DAC_TOP cap_mim_2f0fF W=5e-6 L=5e-6 M=1
C69 RAIL6 DAC_TOP cap_mim_2f0fF W=5e-6 L=5e-6 M=1
C70 RAIL6 DAC_TOP cap_mim_2f0fF W=5e-6 L=5e-6 M=1
C71 RAIL6 DAC_TOP cap_mim_2f0fF W=5e-6 L=5e-6 M=1
C72 RAIL6 DAC_TOP cap_mim_2f0fF W=5e-6 L=5e-6 M=1
C73 RAIL6 DAC_TOP cap_mim_2f0fF W=5e-6 L=5e-6 M=1
C74 RAIL6 DAC_TOP cap_mim_2f0fF W=5e-6 L=5e-6 M=1
C75 RAIL6 DAC_TOP cap_mim_2f0fF W=5e-6 L=5e-6 M=1
C76 RAIL6 DAC_TOP cap_mim_2f0fF W=5e-6 L=5e-6 M=1
C77 RAIL6 DAC_TOP cap_mim_2f0fF W=5e-6 L=5e-6 M=1
C78 RAIL6 DAC_TOP cap_mim_2f0fF W=5e-6 L=5e-6 M=1
C79 RAIL6 DAC_TOP cap_mim_2f0fF W=5e-6 L=5e-6 M=1
C80 RAIL6 DAC_TOP cap_mim_2f0fF W=5e-6 L=5e-6 M=1
C81 RAIL6 DAC_TOP cap_mim_2f0fF W=5e-6 L=5e-6 M=1
C82 RAIL6 DAC_TOP cap_mim_2f0fF W=5e-6 L=5e-6 M=1
C83 RAIL6 DAC_TOP cap_mim_2f0fF W=5e-6 L=5e-6 M=1
C84 RAIL6 DAC_TOP cap_mim_2f0fF W=5e-6 L=5e-6 M=1
C85 RAIL6 DAC_TOP cap_mim_2f0fF W=5e-6 L=5e-6 M=1
C86 RAIL6 DAC_TOP cap_mim_2f0fF W=5e-6 L=5e-6 M=1
C87 RAIL6 DAC_TOP cap_mim_2f0fF W=5e-6 L=5e-6 M=1
C88 RAIL6 DAC_TOP cap_mim_2f0fF W=5e-6 L=5e-6 M=1
C89 RAIL6 DAC_TOP cap_mim_2f0fF W=5e-6 L=5e-6 M=1
C90 RAIL6 DAC_TOP cap_mim_2f0fF W=5e-6 L=5e-6 M=1
C91 RAIL6 DAC_TOP cap_mim_2f0fF W=5e-6 L=5e-6 M=1
C92 RAIL6 DAC_TOP cap_mim_2f0fF W=5e-6 L=5e-6 M=1
C93 RAIL6 DAC_TOP cap_mim_2f0fF W=5e-6 L=5e-6 M=1
C94 RAIL6 DAC_TOP cap_mim_2f0fF W=5e-6 L=5e-6 M=1
C95 RAIL6 DAC_TOP cap_mim_2f0fF W=5e-6 L=5e-6 M=1
C96 RAIL6 DAC_TOP cap_mim_2f0fF W=5e-6 L=5e-6 M=1
C97 RAIL6 DAC_TOP cap_mim_2f0fF W=5e-6 L=5e-6 M=1
C98 RAIL6 DAC_TOP cap_mim_2f0fF W=5e-6 L=5e-6 M=1
C99 RAIL6 DAC_TOP cap_mim_2f0fF W=5e-6 L=5e-6 M=1
C100 RAIL6 DAC_TOP cap_mim_2f0fF W=5e-6 L=5e-6 M=1
C101 RAIL6 DAC_TOP cap_mim_2f0fF W=5e-6 L=5e-6 M=1
C102 RAIL6 DAC_TOP cap_mim_2f0fF W=5e-6 L=5e-6 M=1
C103 RAIL6 DAC_TOP cap_mim_2f0fF W=5e-6 L=5e-6 M=1
C104 RAIL6 DAC_TOP cap_mim_2f0fF W=5e-6 L=5e-6 M=1
C105 RAIL6 DAC_TOP cap_mim_2f0fF W=5e-6 L=5e-6 M=1
C106 RAIL6 DAC_TOP cap_mim_2f0fF W=5e-6 L=5e-6 M=1
C107 RAIL6 DAC_TOP cap_mim_2f0fF W=5e-6 L=5e-6 M=1
C108 RAIL6 DAC_TOP cap_mim_2f0fF W=5e-6 L=5e-6 M=1
C109 RAIL6 DAC_TOP cap_mim_2f0fF W=5e-6 L=5e-6 M=1
C110 RAIL6 DAC_TOP cap_mim_2f0fF W=5e-6 L=5e-6 M=1
C111 RAIL6 DAC_TOP cap_mim_2f0fF W=5e-6 L=5e-6 M=1
C112 RAIL6 DAC_TOP cap_mim_2f0fF W=5e-6 L=5e-6 M=1
C113 RAIL6 DAC_TOP cap_mim_2f0fF W=5e-6 L=5e-6 M=1
C114 RAIL6 DAC_TOP cap_mim_2f0fF W=5e-6 L=5e-6 M=1
C115 RAIL6 DAC_TOP cap_mim_2f0fF W=5e-6 L=5e-6 M=1
C116 RAIL6 DAC_TOP cap_mim_2f0fF W=5e-6 L=5e-6 M=1
C117 RAIL6 DAC_TOP cap_mim_2f0fF W=5e-6 L=5e-6 M=1
C118 RAIL6 DAC_TOP cap_mim_2f0fF W=5e-6 L=5e-6 M=1
C119 RAIL6 DAC_TOP cap_mim_2f0fF W=5e-6 L=5e-6 M=1
C120 RAIL6 DAC_TOP cap_mim_2f0fF W=5e-6 L=5e-6 M=1
C121 RAIL6 DAC_TOP cap_mim_2f0fF W=5e-6 L=5e-6 M=1
C122 RAIL6 DAC_TOP cap_mim_2f0fF W=5e-6 L=5e-6 M=1
C123 RAIL6 DAC_TOP cap_mim_2f0fF W=5e-6 L=5e-6 M=1
C124 RAIL6 DAC_TOP cap_mim_2f0fF W=5e-6 L=5e-6 M=1
C125 RAIL6 DAC_TOP cap_mim_2f0fF W=5e-6 L=5e-6 M=1
C126 RAIL6 DAC_TOP cap_mim_2f0fF W=5e-6 L=5e-6 M=1
C127 RAIL6 DAC_TOP cap_mim_2f0fF W=5e-6 L=5e-6 M=1
C128 RAIL7 DAC_TOP cap_mim_2f0fF W=5e-6 L=5e-6 M=1
C129 RAIL7 DAC_TOP cap_mim_2f0fF W=5e-6 L=5e-6 M=1
C130 RAIL7 DAC_TOP cap_mim_2f0fF W=5e-6 L=5e-6 M=1
C131 RAIL7 DAC_TOP cap_mim_2f0fF W=5e-6 L=5e-6 M=1
C132 RAIL7 DAC_TOP cap_mim_2f0fF W=5e-6 L=5e-6 M=1
C133 RAIL7 DAC_TOP cap_mim_2f0fF W=5e-6 L=5e-6 M=1
C134 RAIL7 DAC_TOP cap_mim_2f0fF W=5e-6 L=5e-6 M=1
C135 RAIL7 DAC_TOP cap_mim_2f0fF W=5e-6 L=5e-6 M=1
C136 RAIL7 DAC_TOP cap_mim_2f0fF W=5e-6 L=5e-6 M=1
C137 RAIL7 DAC_TOP cap_mim_2f0fF W=5e-6 L=5e-6 M=1
C138 RAIL7 DAC_TOP cap_mim_2f0fF W=5e-6 L=5e-6 M=1
C139 RAIL7 DAC_TOP cap_mim_2f0fF W=5e-6 L=5e-6 M=1
C140 RAIL7 DAC_TOP cap_mim_2f0fF W=5e-6 L=5e-6 M=1
C141 RAIL7 DAC_TOP cap_mim_2f0fF W=5e-6 L=5e-6 M=1
C142 RAIL7 DAC_TOP cap_mim_2f0fF W=5e-6 L=5e-6 M=1
C143 RAIL7 DAC_TOP cap_mim_2f0fF W=5e-6 L=5e-6 M=1
C144 RAIL7 DAC_TOP cap_mim_2f0fF W=5e-6 L=5e-6 M=1
C145 RAIL7 DAC_TOP cap_mim_2f0fF W=5e-6 L=5e-6 M=1
C146 RAIL7 DAC_TOP cap_mim_2f0fF W=5e-6 L=5e-6 M=1
C147 RAIL7 DAC_TOP cap_mim_2f0fF W=5e-6 L=5e-6 M=1
C148 RAIL7 DAC_TOP cap_mim_2f0fF W=5e-6 L=5e-6 M=1
C149 RAIL7 DAC_TOP cap_mim_2f0fF W=5e-6 L=5e-6 M=1
C150 RAIL7 DAC_TOP cap_mim_2f0fF W=5e-6 L=5e-6 M=1
C151 RAIL7 DAC_TOP cap_mim_2f0fF W=5e-6 L=5e-6 M=1
C152 RAIL7 DAC_TOP cap_mim_2f0fF W=5e-6 L=5e-6 M=1
C153 RAIL7 DAC_TOP cap_mim_2f0fF W=5e-6 L=5e-6 M=1
C154 RAIL7 DAC_TOP cap_mim_2f0fF W=5e-6 L=5e-6 M=1
C155 RAIL7 DAC_TOP cap_mim_2f0fF W=5e-6 L=5e-6 M=1
C156 RAIL7 DAC_TOP cap_mim_2f0fF W=5e-6 L=5e-6 M=1
C157 RAIL7 DAC_TOP cap_mim_2f0fF W=5e-6 L=5e-6 M=1
C158 RAIL7 DAC_TOP cap_mim_2f0fF W=5e-6 L=5e-6 M=1
C159 RAIL7 DAC_TOP cap_mim_2f0fF W=5e-6 L=5e-6 M=1
C160 RAIL7 DAC_TOP cap_mim_2f0fF W=5e-6 L=5e-6 M=1
C161 RAIL7 DAC_TOP cap_mim_2f0fF W=5e-6 L=5e-6 M=1
C162 RAIL7 DAC_TOP cap_mim_2f0fF W=5e-6 L=5e-6 M=1
C163 RAIL7 DAC_TOP cap_mim_2f0fF W=5e-6 L=5e-6 M=1
C164 RAIL7 DAC_TOP cap_mim_2f0fF W=5e-6 L=5e-6 M=1
C165 RAIL7 DAC_TOP cap_mim_2f0fF W=5e-6 L=5e-6 M=1
C166 RAIL7 DAC_TOP cap_mim_2f0fF W=5e-6 L=5e-6 M=1
C167 RAIL7 DAC_TOP cap_mim_2f0fF W=5e-6 L=5e-6 M=1
C168 RAIL7 DAC_TOP cap_mim_2f0fF W=5e-6 L=5e-6 M=1
C169 RAIL7 DAC_TOP cap_mim_2f0fF W=5e-6 L=5e-6 M=1
C170 RAIL7 DAC_TOP cap_mim_2f0fF W=5e-6 L=5e-6 M=1
C171 RAIL7 DAC_TOP cap_mim_2f0fF W=5e-6 L=5e-6 M=1
C172 RAIL7 DAC_TOP cap_mim_2f0fF W=5e-6 L=5e-6 M=1
C173 RAIL7 DAC_TOP cap_mim_2f0fF W=5e-6 L=5e-6 M=1
C174 RAIL7 DAC_TOP cap_mim_2f0fF W=5e-6 L=5e-6 M=1
C175 RAIL7 DAC_TOP cap_mim_2f0fF W=5e-6 L=5e-6 M=1
C176 RAIL7 DAC_TOP cap_mim_2f0fF W=5e-6 L=5e-6 M=1
C177 RAIL7 DAC_TOP cap_mim_2f0fF W=5e-6 L=5e-6 M=1
C178 RAIL7 DAC_TOP cap_mim_2f0fF W=5e-6 L=5e-6 M=1
C179 RAIL7 DAC_TOP cap_mim_2f0fF W=5e-6 L=5e-6 M=1
C180 RAIL7 DAC_TOP cap_mim_2f0fF W=5e-6 L=5e-6 M=1
C181 RAIL7 DAC_TOP cap_mim_2f0fF W=5e-6 L=5e-6 M=1
C182 RAIL7 DAC_TOP cap_mim_2f0fF W=5e-6 L=5e-6 M=1
C183 RAIL7 DAC_TOP cap_mim_2f0fF W=5e-6 L=5e-6 M=1
C184 RAIL7 DAC_TOP cap_mim_2f0fF W=5e-6 L=5e-6 M=1
C185 RAIL7 DAC_TOP cap_mim_2f0fF W=5e-6 L=5e-6 M=1
C186 RAIL7 DAC_TOP cap_mim_2f0fF W=5e-6 L=5e-6 M=1
C187 RAIL7 DAC_TOP cap_mim_2f0fF W=5e-6 L=5e-6 M=1
C188 RAIL7 DAC_TOP cap_mim_2f0fF W=5e-6 L=5e-6 M=1
C189 RAIL7 DAC_TOP cap_mim_2f0fF W=5e-6 L=5e-6 M=1
C190 RAIL7 DAC_TOP cap_mim_2f0fF W=5e-6 L=5e-6 M=1
C191 RAIL7 DAC_TOP cap_mim_2f0fF W=5e-6 L=5e-6 M=1
C192 RAIL7 DAC_TOP cap_mim_2f0fF W=5e-6 L=5e-6 M=1
C193 RAIL7 DAC_TOP cap_mim_2f0fF W=5e-6 L=5e-6 M=1
C194 RAIL7 DAC_TOP cap_mim_2f0fF W=5e-6 L=5e-6 M=1
C195 RAIL7 DAC_TOP cap_mim_2f0fF W=5e-6 L=5e-6 M=1
C196 RAIL7 DAC_TOP cap_mim_2f0fF W=5e-6 L=5e-6 M=1
C197 RAIL7 DAC_TOP cap_mim_2f0fF W=5e-6 L=5e-6 M=1
C198 RAIL7 DAC_TOP cap_mim_2f0fF W=5e-6 L=5e-6 M=1
C199 RAIL7 DAC_TOP cap_mim_2f0fF W=5e-6 L=5e-6 M=1
C200 RAIL7 DAC_TOP cap_mim_2f0fF W=5e-6 L=5e-6 M=1
C201 RAIL7 DAC_TOP cap_mim_2f0fF W=5e-6 L=5e-6 M=1
C202 RAIL7 DAC_TOP cap_mim_2f0fF W=5e-6 L=5e-6 M=1
C203 RAIL7 DAC_TOP cap_mim_2f0fF W=5e-6 L=5e-6 M=1
C204 RAIL7 DAC_TOP cap_mim_2f0fF W=5e-6 L=5e-6 M=1
C205 RAIL7 DAC_TOP cap_mim_2f0fF W=5e-6 L=5e-6 M=1
C206 RAIL7 DAC_TOP cap_mim_2f0fF W=5e-6 L=5e-6 M=1
C207 RAIL7 DAC_TOP cap_mim_2f0fF W=5e-6 L=5e-6 M=1
C208 RAIL7 DAC_TOP cap_mim_2f0fF W=5e-6 L=5e-6 M=1
C209 RAIL7 DAC_TOP cap_mim_2f0fF W=5e-6 L=5e-6 M=1
C210 RAIL7 DAC_TOP cap_mim_2f0fF W=5e-6 L=5e-6 M=1
C211 RAIL7 DAC_TOP cap_mim_2f0fF W=5e-6 L=5e-6 M=1
C212 RAIL7 DAC_TOP cap_mim_2f0fF W=5e-6 L=5e-6 M=1
C213 RAIL7 DAC_TOP cap_mim_2f0fF W=5e-6 L=5e-6 M=1
C214 RAIL7 DAC_TOP cap_mim_2f0fF W=5e-6 L=5e-6 M=1
C215 RAIL7 DAC_TOP cap_mim_2f0fF W=5e-6 L=5e-6 M=1
C216 RAIL7 DAC_TOP cap_mim_2f0fF W=5e-6 L=5e-6 M=1
C217 RAIL7 DAC_TOP cap_mim_2f0fF W=5e-6 L=5e-6 M=1
C218 RAIL7 DAC_TOP cap_mim_2f0fF W=5e-6 L=5e-6 M=1
C219 RAIL7 DAC_TOP cap_mim_2f0fF W=5e-6 L=5e-6 M=1
C220 RAIL7 DAC_TOP cap_mim_2f0fF W=5e-6 L=5e-6 M=1
C221 RAIL7 DAC_TOP cap_mim_2f0fF W=5e-6 L=5e-6 M=1
C222 RAIL7 DAC_TOP cap_mim_2f0fF W=5e-6 L=5e-6 M=1
C223 RAIL7 DAC_TOP cap_mim_2f0fF W=5e-6 L=5e-6 M=1
C224 RAIL7 DAC_TOP cap_mim_2f0fF W=5e-6 L=5e-6 M=1
C225 RAIL7 DAC_TOP cap_mim_2f0fF W=5e-6 L=5e-6 M=1
C226 RAIL7 DAC_TOP cap_mim_2f0fF W=5e-6 L=5e-6 M=1
C227 RAIL7 DAC_TOP cap_mim_2f0fF W=5e-6 L=5e-6 M=1
C228 RAIL7 DAC_TOP cap_mim_2f0fF W=5e-6 L=5e-6 M=1
C229 RAIL7 DAC_TOP cap_mim_2f0fF W=5e-6 L=5e-6 M=1
C230 RAIL7 DAC_TOP cap_mim_2f0fF W=5e-6 L=5e-6 M=1
C231 RAIL7 DAC_TOP cap_mim_2f0fF W=5e-6 L=5e-6 M=1
C232 RAIL7 DAC_TOP cap_mim_2f0fF W=5e-6 L=5e-6 M=1
C233 RAIL7 DAC_TOP cap_mim_2f0fF W=5e-6 L=5e-6 M=1
C234 RAIL7 DAC_TOP cap_mim_2f0fF W=5e-6 L=5e-6 M=1
C235 RAIL7 DAC_TOP cap_mim_2f0fF W=5e-6 L=5e-6 M=1
C236 RAIL7 DAC_TOP cap_mim_2f0fF W=5e-6 L=5e-6 M=1
C237 RAIL7 DAC_TOP cap_mim_2f0fF W=5e-6 L=5e-6 M=1
C238 RAIL7 DAC_TOP cap_mim_2f0fF W=5e-6 L=5e-6 M=1
C239 RAIL7 DAC_TOP cap_mim_2f0fF W=5e-6 L=5e-6 M=1
C240 RAIL7 DAC_TOP cap_mim_2f0fF W=5e-6 L=5e-6 M=1
C241 RAIL7 DAC_TOP cap_mim_2f0fF W=5e-6 L=5e-6 M=1
C242 RAIL7 DAC_TOP cap_mim_2f0fF W=5e-6 L=5e-6 M=1
C243 RAIL7 DAC_TOP cap_mim_2f0fF W=5e-6 L=5e-6 M=1
C244 RAIL7 DAC_TOP cap_mim_2f0fF W=5e-6 L=5e-6 M=1
C245 RAIL7 DAC_TOP cap_mim_2f0fF W=5e-6 L=5e-6 M=1
C246 RAIL7 DAC_TOP cap_mim_2f0fF W=5e-6 L=5e-6 M=1
C247 RAIL7 DAC_TOP cap_mim_2f0fF W=5e-6 L=5e-6 M=1
C248 RAIL7 DAC_TOP cap_mim_2f0fF W=5e-6 L=5e-6 M=1
C249 RAIL7 DAC_TOP cap_mim_2f0fF W=5e-6 L=5e-6 M=1
C250 RAIL7 DAC_TOP cap_mim_2f0fF W=5e-6 L=5e-6 M=1
C251 RAIL7 DAC_TOP cap_mim_2f0fF W=5e-6 L=5e-6 M=1
C252 RAIL7 DAC_TOP cap_mim_2f0fF W=5e-6 L=5e-6 M=1
C253 RAIL7 DAC_TOP cap_mim_2f0fF W=5e-6 L=5e-6 M=1
C254 RAIL7 DAC_TOP cap_mim_2f0fF W=5e-6 L=5e-6 M=1
C255 RAIL7 DAC_TOP cap_mim_2f0fF W=5e-6 L=5e-6 M=1
MIP SAMPLE_N SAMPLE VDD VDD pfet_03v3 L=0.3u W=1.7u nf=1
MIN SAMPLE_N SAMPLE VSS VSS nfet_03v3 L=0.3u W=0.85u nf=1
MTN VIN SAMPLE DAC_TOP VSS nfet_03v3 L=0.28u W=4u nf=1
MTP DAC_TOP SAMPLE_N VIN VDD pfet_03v3 L=0.28u W=8u nf=1
C256 VSS VSS cap_mim_2f0fF W=5e-6 L=5e-6 M=1
C257 VSS VSS cap_mim_2f0fF W=5e-6 L=5e-6 M=1
C258 VSS VSS cap_mim_2f0fF W=5e-6 L=5e-6 M=1
C259 VSS VSS cap_mim_2f0fF W=5e-6 L=5e-6 M=1
C260 VSS VSS cap_mim_2f0fF W=5e-6 L=5e-6 M=1
C261 VSS VSS cap_mim_2f0fF W=5e-6 L=5e-6 M=1
C262 VSS VSS cap_mim_2f0fF W=5e-6 L=5e-6 M=1
C263 VSS VSS cap_mim_2f0fF W=5e-6 L=5e-6 M=1
C264 VSS VSS cap_mim_2f0fF W=5e-6 L=5e-6 M=1
C265 VSS VSS cap_mim_2f0fF W=5e-6 L=5e-6 M=1
C266 VSS VSS cap_mim_2f0fF W=5e-6 L=5e-6 M=1
C267 VSS VSS cap_mim_2f0fF W=5e-6 L=5e-6 M=1
C268 VSS VSS cap_mim_2f0fF W=5e-6 L=5e-6 M=1
C269 VSS VSS cap_mim_2f0fF W=5e-6 L=5e-6 M=1
C270 VSS VSS cap_mim_2f0fF W=5e-6 L=5e-6 M=1
C271 VSS VSS cap_mim_2f0fF W=5e-6 L=5e-6 M=1
C272 VSS VSS cap_mim_2f0fF W=5e-6 L=5e-6 M=1
C273 VSS VSS cap_mim_2f0fF W=5e-6 L=5e-6 M=1
C274 VSS VSS cap_mim_2f0fF W=5e-6 L=5e-6 M=1
C275 VSS VSS cap_mim_2f0fF W=5e-6 L=5e-6 M=1
C276 VSS VSS cap_mim_2f0fF W=5e-6 L=5e-6 M=1
C277 VSS VSS cap_mim_2f0fF W=5e-6 L=5e-6 M=1
C278 VSS VSS cap_mim_2f0fF W=5e-6 L=5e-6 M=1
C279 VSS VSS cap_mim_2f0fF W=5e-6 L=5e-6 M=1
C280 VSS VSS cap_mim_2f0fF W=5e-6 L=5e-6 M=1
C281 VSS VSS cap_mim_2f0fF W=5e-6 L=5e-6 M=1
C282 VSS VSS cap_mim_2f0fF W=5e-6 L=5e-6 M=1
C283 VSS VSS cap_mim_2f0fF W=5e-6 L=5e-6 M=1
C284 VSS VSS cap_mim_2f0fF W=5e-6 L=5e-6 M=1
C285 VSS VSS cap_mim_2f0fF W=5e-6 L=5e-6 M=1
C286 VSS VSS cap_mim_2f0fF W=5e-6 L=5e-6 M=1
C287 VSS VSS cap_mim_2f0fF W=5e-6 L=5e-6 M=1
C288 VSS VSS cap_mim_2f0fF W=5e-6 L=5e-6 M=1
C289 VSS VSS cap_mim_2f0fF W=5e-6 L=5e-6 M=1
C290 VSS VSS cap_mim_2f0fF W=5e-6 L=5e-6 M=1
C291 VSS VSS cap_mim_2f0fF W=5e-6 L=5e-6 M=1
C292 VSS VSS cap_mim_2f0fF W=5e-6 L=5e-6 M=1
C293 VSS VSS cap_mim_2f0fF W=5e-6 L=5e-6 M=1
C294 VSS VSS cap_mim_2f0fF W=5e-6 L=5e-6 M=1
C295 VSS VSS cap_mim_2f0fF W=5e-6 L=5e-6 M=1
C296 VSS VSS cap_mim_2f0fF W=5e-6 L=5e-6 M=1
C297 VSS VSS cap_mim_2f0fF W=5e-6 L=5e-6 M=1
C298 VSS VSS cap_mim_2f0fF W=5e-6 L=5e-6 M=1
C299 VSS VSS cap_mim_2f0fF W=5e-6 L=5e-6 M=1
C300 VSS VSS cap_mim_2f0fF W=5e-6 L=5e-6 M=1
C301 VSS VSS cap_mim_2f0fF W=5e-6 L=5e-6 M=1
C302 VSS VSS cap_mim_2f0fF W=5e-6 L=5e-6 M=1
C303 VSS VSS cap_mim_2f0fF W=5e-6 L=5e-6 M=1
C304 VSS VSS cap_mim_2f0fF W=5e-6 L=5e-6 M=1
C305 VSS VSS cap_mim_2f0fF W=5e-6 L=5e-6 M=1
C306 VSS VSS cap_mim_2f0fF W=5e-6 L=5e-6 M=1
C307 VSS VSS cap_mim_2f0fF W=5e-6 L=5e-6 M=1
C308 VSS VSS cap_mim_2f0fF W=5e-6 L=5e-6 M=1
C309 VSS VSS cap_mim_2f0fF W=5e-6 L=5e-6 M=1
C310 VSS VSS cap_mim_2f0fF W=5e-6 L=5e-6 M=1
C311 VSS VSS cap_mim_2f0fF W=5e-6 L=5e-6 M=1
C312 VSS VSS cap_mim_2f0fF W=5e-6 L=5e-6 M=1
C313 VSS VSS cap_mim_2f0fF W=5e-6 L=5e-6 M=1
C314 VSS VSS cap_mim_2f0fF W=5e-6 L=5e-6 M=1
C315 VSS VSS cap_mim_2f0fF W=5e-6 L=5e-6 M=1
C316 VSS VSS cap_mim_2f0fF W=5e-6 L=5e-6 M=1
C317 VSS VSS cap_mim_2f0fF W=5e-6 L=5e-6 M=1
C318 VSS VSS cap_mim_2f0fF W=5e-6 L=5e-6 M=1
C319 VSS VSS cap_mim_2f0fF W=5e-6 L=5e-6 M=1
C320 VSS VSS cap_mim_2f0fF W=5e-6 L=5e-6 M=1
C321 VSS VSS cap_mim_2f0fF W=5e-6 L=5e-6 M=1
C322 VSS VSS cap_mim_2f0fF W=5e-6 L=5e-6 M=1
C323 VSS VSS cap_mim_2f0fF W=5e-6 L=5e-6 M=1
C324 VSS VSS cap_mim_2f0fF W=5e-6 L=5e-6 M=1
.ends dac_top_floorplan
.subckt adc_glue CLK CK RST_N SAMPLE VOUT1 VOUT2 CMP_OUT VDD VSS
x_inv_ck VDD CLK CK VSS inv
x_inv_smp VDD RST_N SAMPLE VSS inv
x_ib1 VDD VOUT1 V1B VSS inv
x_ib2 VDD VOUT2 V2B VSS inv
x_nq VDD V2B QB CMP_OUT VSS nor2
x_nqb VDD V1B CMP_OUT QB VSS nor2
.ends
.subckt adc_top VDD VSS VIN CLK RST_N BIT_7 BIT_6 BIT_5 BIT_4 BIT_3 BIT_2 BIT_1 BIT_0 EOC
x_dac VSS VDD SAMPLE BIT_0 BIT_1 BIT_2 BIT_3 BIT_4 BIT_5 BIT_6 BIT_7 DAC_TOP VSS dac_top_floorplan
x_cmp VDD CK VOUT2 VOUT1 VIN DAC_TOP VSS strongarm
x_sar VDD VSS BIT_7 BIT_6 BIT_5 BIT_4 BIT_3 BIT_2 BIT_1 BIT_0 EOC RST_N CMP_OUT CLK sar_logic
x_glue CLK CK RST_N SAMPLE VOUT1 VOUT2 CMP_OUT VDD VSS adc_glue
.ends
