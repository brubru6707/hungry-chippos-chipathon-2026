* INT-6 Gate-3 sweep chunk 5: codes 160..191 (TT, 3.3 V, 10 MHz)
.include /foss/pdks/gf180mcuD/libs.tech/ngspice/design.ngspice
.lib /foss/pdks/gf180mcuD/libs.tech/ngspice/sm141064.ngspice typical
.lib /foss/pdks/gf180mcuD/libs.tech/ngspice/sm141064.ngspice mimcap_typical
.lib /foss/pdks/gf180mcuD/libs.tech/ngspice/sm141064.ngspice cap_mim
.lib /foss/pdks/gf180mcuD/libs.tech/ngspice/smbb000149.ngspice typical

.include ../adc_top_bcmp_subckt.spice

VVDD VDD 0 3.3
VCLK CLK 0 PULSE(0 3.3 0 1n 1n 49n 100n)
VRST RST_N 0 PULSE(3.3 0 0 1n 1n 120n 1200n)
VVIN vin 0 PWL(0 2.064557 1198n 2.064557 1200n 2.077420 2398n 2.077420 2400n 2.090283 3598n 2.090283 3600n 2.103146 4798n 2.103146 4800n 2.116010 5998n 2.116010 6000n 2.128873 7198n 2.128873 7200n 2.141736 8398n 2.141736 8400n 2.154600 9598n 2.154600 9600n 2.167463 10798n 2.167463 10800n 2.180326 11998n 2.180326 12000n 2.193189 13198n 2.193189 13200n 2.206053 14398n 2.206053 14400n 2.218916 15598n 2.218916 15600n 2.231779 16798n 2.231779 16800n 2.244643 17998n 2.244643 18000n 2.257506 19198n 2.257506 19200n 2.270369 20398n 2.270369 20400n 2.283232 21598n 2.283232 21600n 2.296096 22798n 2.296096 22800n 2.308959 23998n 2.308959 24000n 2.321822 25198n 2.321822 25200n 2.334686 26398n 2.334686 26400n 2.347549 27598n 2.347549 27600n 2.360412 28798n 2.360412 28800n 2.373275 29998n 2.373275 30000n 2.386139 31198n 2.386139 31200n 2.399002 32398n 2.399002 32400n 2.411865 33598n 2.411865 33600n 2.424729 34798n 2.424729 34800n 2.437592 35998n 2.437592 36000n 2.450455 37198n 2.450455 37200n 2.463318 38398n 2.463318)

Xadc VDD 0 vin CLK RST_N BIT_7 BIT_6 BIT_5 BIT_4 BIT_3 BIT_2 BIT_1 BIT_0 EOC adc_top_bcmp

CB7 BIT_7 0 20f
CB6 BIT_6 0 20f
CB5 BIT_5 0 20f
CB4 BIT_4 0 20f
CB3 BIT_3 0 20f
CB2 BIT_2 0 20f
CB1 BIT_1 0 20f
CB0 BIT_0 0 20f
CEOC EOC 0 20f

.tran 0.1n 38.4u
.meas tran eoc_160 FIND V(EOC) AT=950n
.meas tran b0_160 FIND V(BIT_0) AT=950n
.meas tran b1_160 FIND V(BIT_1) AT=950n
.meas tran b2_160 FIND V(BIT_2) AT=950n
.meas tran b3_160 FIND V(BIT_3) AT=950n
.meas tran b4_160 FIND V(BIT_4) AT=950n
.meas tran b5_160 FIND V(BIT_5) AT=950n
.meas tran b6_160 FIND V(BIT_6) AT=950n
.meas tran b7_160 FIND V(BIT_7) AT=950n
.meas tran eoc_161 FIND V(EOC) AT=2150n
.meas tran b0_161 FIND V(BIT_0) AT=2150n
.meas tran b1_161 FIND V(BIT_1) AT=2150n
.meas tran b2_161 FIND V(BIT_2) AT=2150n
.meas tran b3_161 FIND V(BIT_3) AT=2150n
.meas tran b4_161 FIND V(BIT_4) AT=2150n
.meas tran b5_161 FIND V(BIT_5) AT=2150n
.meas tran b6_161 FIND V(BIT_6) AT=2150n
.meas tran b7_161 FIND V(BIT_7) AT=2150n
.meas tran eoc_162 FIND V(EOC) AT=3350n
.meas tran b0_162 FIND V(BIT_0) AT=3350n
.meas tran b1_162 FIND V(BIT_1) AT=3350n
.meas tran b2_162 FIND V(BIT_2) AT=3350n
.meas tran b3_162 FIND V(BIT_3) AT=3350n
.meas tran b4_162 FIND V(BIT_4) AT=3350n
.meas tran b5_162 FIND V(BIT_5) AT=3350n
.meas tran b6_162 FIND V(BIT_6) AT=3350n
.meas tran b7_162 FIND V(BIT_7) AT=3350n
.meas tran eoc_163 FIND V(EOC) AT=4550n
.meas tran b0_163 FIND V(BIT_0) AT=4550n
.meas tran b1_163 FIND V(BIT_1) AT=4550n
.meas tran b2_163 FIND V(BIT_2) AT=4550n
.meas tran b3_163 FIND V(BIT_3) AT=4550n
.meas tran b4_163 FIND V(BIT_4) AT=4550n
.meas tran b5_163 FIND V(BIT_5) AT=4550n
.meas tran b6_163 FIND V(BIT_6) AT=4550n
.meas tran b7_163 FIND V(BIT_7) AT=4550n
.meas tran eoc_164 FIND V(EOC) AT=5750n
.meas tran b0_164 FIND V(BIT_0) AT=5750n
.meas tran b1_164 FIND V(BIT_1) AT=5750n
.meas tran b2_164 FIND V(BIT_2) AT=5750n
.meas tran b3_164 FIND V(BIT_3) AT=5750n
.meas tran b4_164 FIND V(BIT_4) AT=5750n
.meas tran b5_164 FIND V(BIT_5) AT=5750n
.meas tran b6_164 FIND V(BIT_6) AT=5750n
.meas tran b7_164 FIND V(BIT_7) AT=5750n
.meas tran eoc_165 FIND V(EOC) AT=6950n
.meas tran b0_165 FIND V(BIT_0) AT=6950n
.meas tran b1_165 FIND V(BIT_1) AT=6950n
.meas tran b2_165 FIND V(BIT_2) AT=6950n
.meas tran b3_165 FIND V(BIT_3) AT=6950n
.meas tran b4_165 FIND V(BIT_4) AT=6950n
.meas tran b5_165 FIND V(BIT_5) AT=6950n
.meas tran b6_165 FIND V(BIT_6) AT=6950n
.meas tran b7_165 FIND V(BIT_7) AT=6950n
.meas tran eoc_166 FIND V(EOC) AT=8150n
.meas tran b0_166 FIND V(BIT_0) AT=8150n
.meas tran b1_166 FIND V(BIT_1) AT=8150n
.meas tran b2_166 FIND V(BIT_2) AT=8150n
.meas tran b3_166 FIND V(BIT_3) AT=8150n
.meas tran b4_166 FIND V(BIT_4) AT=8150n
.meas tran b5_166 FIND V(BIT_5) AT=8150n
.meas tran b6_166 FIND V(BIT_6) AT=8150n
.meas tran b7_166 FIND V(BIT_7) AT=8150n
.meas tran eoc_167 FIND V(EOC) AT=9350n
.meas tran b0_167 FIND V(BIT_0) AT=9350n
.meas tran b1_167 FIND V(BIT_1) AT=9350n
.meas tran b2_167 FIND V(BIT_2) AT=9350n
.meas tran b3_167 FIND V(BIT_3) AT=9350n
.meas tran b4_167 FIND V(BIT_4) AT=9350n
.meas tran b5_167 FIND V(BIT_5) AT=9350n
.meas tran b6_167 FIND V(BIT_6) AT=9350n
.meas tran b7_167 FIND V(BIT_7) AT=9350n
.meas tran eoc_168 FIND V(EOC) AT=10550n
.meas tran b0_168 FIND V(BIT_0) AT=10550n
.meas tran b1_168 FIND V(BIT_1) AT=10550n
.meas tran b2_168 FIND V(BIT_2) AT=10550n
.meas tran b3_168 FIND V(BIT_3) AT=10550n
.meas tran b4_168 FIND V(BIT_4) AT=10550n
.meas tran b5_168 FIND V(BIT_5) AT=10550n
.meas tran b6_168 FIND V(BIT_6) AT=10550n
.meas tran b7_168 FIND V(BIT_7) AT=10550n
.meas tran eoc_169 FIND V(EOC) AT=11750n
.meas tran b0_169 FIND V(BIT_0) AT=11750n
.meas tran b1_169 FIND V(BIT_1) AT=11750n
.meas tran b2_169 FIND V(BIT_2) AT=11750n
.meas tran b3_169 FIND V(BIT_3) AT=11750n
.meas tran b4_169 FIND V(BIT_4) AT=11750n
.meas tran b5_169 FIND V(BIT_5) AT=11750n
.meas tran b6_169 FIND V(BIT_6) AT=11750n
.meas tran b7_169 FIND V(BIT_7) AT=11750n
.meas tran eoc_170 FIND V(EOC) AT=12950n
.meas tran b0_170 FIND V(BIT_0) AT=12950n
.meas tran b1_170 FIND V(BIT_1) AT=12950n
.meas tran b2_170 FIND V(BIT_2) AT=12950n
.meas tran b3_170 FIND V(BIT_3) AT=12950n
.meas tran b4_170 FIND V(BIT_4) AT=12950n
.meas tran b5_170 FIND V(BIT_5) AT=12950n
.meas tran b6_170 FIND V(BIT_6) AT=12950n
.meas tran b7_170 FIND V(BIT_7) AT=12950n
.meas tran eoc_171 FIND V(EOC) AT=14150n
.meas tran b0_171 FIND V(BIT_0) AT=14150n
.meas tran b1_171 FIND V(BIT_1) AT=14150n
.meas tran b2_171 FIND V(BIT_2) AT=14150n
.meas tran b3_171 FIND V(BIT_3) AT=14150n
.meas tran b4_171 FIND V(BIT_4) AT=14150n
.meas tran b5_171 FIND V(BIT_5) AT=14150n
.meas tran b6_171 FIND V(BIT_6) AT=14150n
.meas tran b7_171 FIND V(BIT_7) AT=14150n
.meas tran eoc_172 FIND V(EOC) AT=15350n
.meas tran b0_172 FIND V(BIT_0) AT=15350n
.meas tran b1_172 FIND V(BIT_1) AT=15350n
.meas tran b2_172 FIND V(BIT_2) AT=15350n
.meas tran b3_172 FIND V(BIT_3) AT=15350n
.meas tran b4_172 FIND V(BIT_4) AT=15350n
.meas tran b5_172 FIND V(BIT_5) AT=15350n
.meas tran b6_172 FIND V(BIT_6) AT=15350n
.meas tran b7_172 FIND V(BIT_7) AT=15350n
.meas tran eoc_173 FIND V(EOC) AT=16550n
.meas tran b0_173 FIND V(BIT_0) AT=16550n
.meas tran b1_173 FIND V(BIT_1) AT=16550n
.meas tran b2_173 FIND V(BIT_2) AT=16550n
.meas tran b3_173 FIND V(BIT_3) AT=16550n
.meas tran b4_173 FIND V(BIT_4) AT=16550n
.meas tran b5_173 FIND V(BIT_5) AT=16550n
.meas tran b6_173 FIND V(BIT_6) AT=16550n
.meas tran b7_173 FIND V(BIT_7) AT=16550n
.meas tran eoc_174 FIND V(EOC) AT=17750n
.meas tran b0_174 FIND V(BIT_0) AT=17750n
.meas tran b1_174 FIND V(BIT_1) AT=17750n
.meas tran b2_174 FIND V(BIT_2) AT=17750n
.meas tran b3_174 FIND V(BIT_3) AT=17750n
.meas tran b4_174 FIND V(BIT_4) AT=17750n
.meas tran b5_174 FIND V(BIT_5) AT=17750n
.meas tran b6_174 FIND V(BIT_6) AT=17750n
.meas tran b7_174 FIND V(BIT_7) AT=17750n
.meas tran eoc_175 FIND V(EOC) AT=18950n
.meas tran b0_175 FIND V(BIT_0) AT=18950n
.meas tran b1_175 FIND V(BIT_1) AT=18950n
.meas tran b2_175 FIND V(BIT_2) AT=18950n
.meas tran b3_175 FIND V(BIT_3) AT=18950n
.meas tran b4_175 FIND V(BIT_4) AT=18950n
.meas tran b5_175 FIND V(BIT_5) AT=18950n
.meas tran b6_175 FIND V(BIT_6) AT=18950n
.meas tran b7_175 FIND V(BIT_7) AT=18950n
.meas tran eoc_176 FIND V(EOC) AT=20150n
.meas tran b0_176 FIND V(BIT_0) AT=20150n
.meas tran b1_176 FIND V(BIT_1) AT=20150n
.meas tran b2_176 FIND V(BIT_2) AT=20150n
.meas tran b3_176 FIND V(BIT_3) AT=20150n
.meas tran b4_176 FIND V(BIT_4) AT=20150n
.meas tran b5_176 FIND V(BIT_5) AT=20150n
.meas tran b6_176 FIND V(BIT_6) AT=20150n
.meas tran b7_176 FIND V(BIT_7) AT=20150n
.meas tran eoc_177 FIND V(EOC) AT=21350n
.meas tran b0_177 FIND V(BIT_0) AT=21350n
.meas tran b1_177 FIND V(BIT_1) AT=21350n
.meas tran b2_177 FIND V(BIT_2) AT=21350n
.meas tran b3_177 FIND V(BIT_3) AT=21350n
.meas tran b4_177 FIND V(BIT_4) AT=21350n
.meas tran b5_177 FIND V(BIT_5) AT=21350n
.meas tran b6_177 FIND V(BIT_6) AT=21350n
.meas tran b7_177 FIND V(BIT_7) AT=21350n
.meas tran eoc_178 FIND V(EOC) AT=22550n
.meas tran b0_178 FIND V(BIT_0) AT=22550n
.meas tran b1_178 FIND V(BIT_1) AT=22550n
.meas tran b2_178 FIND V(BIT_2) AT=22550n
.meas tran b3_178 FIND V(BIT_3) AT=22550n
.meas tran b4_178 FIND V(BIT_4) AT=22550n
.meas tran b5_178 FIND V(BIT_5) AT=22550n
.meas tran b6_178 FIND V(BIT_6) AT=22550n
.meas tran b7_178 FIND V(BIT_7) AT=22550n
.meas tran eoc_179 FIND V(EOC) AT=23750n
.meas tran b0_179 FIND V(BIT_0) AT=23750n
.meas tran b1_179 FIND V(BIT_1) AT=23750n
.meas tran b2_179 FIND V(BIT_2) AT=23750n
.meas tran b3_179 FIND V(BIT_3) AT=23750n
.meas tran b4_179 FIND V(BIT_4) AT=23750n
.meas tran b5_179 FIND V(BIT_5) AT=23750n
.meas tran b6_179 FIND V(BIT_6) AT=23750n
.meas tran b7_179 FIND V(BIT_7) AT=23750n
.meas tran eoc_180 FIND V(EOC) AT=24950n
.meas tran b0_180 FIND V(BIT_0) AT=24950n
.meas tran b1_180 FIND V(BIT_1) AT=24950n
.meas tran b2_180 FIND V(BIT_2) AT=24950n
.meas tran b3_180 FIND V(BIT_3) AT=24950n
.meas tran b4_180 FIND V(BIT_4) AT=24950n
.meas tran b5_180 FIND V(BIT_5) AT=24950n
.meas tran b6_180 FIND V(BIT_6) AT=24950n
.meas tran b7_180 FIND V(BIT_7) AT=24950n
.meas tran eoc_181 FIND V(EOC) AT=26150n
.meas tran b0_181 FIND V(BIT_0) AT=26150n
.meas tran b1_181 FIND V(BIT_1) AT=26150n
.meas tran b2_181 FIND V(BIT_2) AT=26150n
.meas tran b3_181 FIND V(BIT_3) AT=26150n
.meas tran b4_181 FIND V(BIT_4) AT=26150n
.meas tran b5_181 FIND V(BIT_5) AT=26150n
.meas tran b6_181 FIND V(BIT_6) AT=26150n
.meas tran b7_181 FIND V(BIT_7) AT=26150n
.meas tran eoc_182 FIND V(EOC) AT=27350n
.meas tran b0_182 FIND V(BIT_0) AT=27350n
.meas tran b1_182 FIND V(BIT_1) AT=27350n
.meas tran b2_182 FIND V(BIT_2) AT=27350n
.meas tran b3_182 FIND V(BIT_3) AT=27350n
.meas tran b4_182 FIND V(BIT_4) AT=27350n
.meas tran b5_182 FIND V(BIT_5) AT=27350n
.meas tran b6_182 FIND V(BIT_6) AT=27350n
.meas tran b7_182 FIND V(BIT_7) AT=27350n
.meas tran eoc_183 FIND V(EOC) AT=28550n
.meas tran b0_183 FIND V(BIT_0) AT=28550n
.meas tran b1_183 FIND V(BIT_1) AT=28550n
.meas tran b2_183 FIND V(BIT_2) AT=28550n
.meas tran b3_183 FIND V(BIT_3) AT=28550n
.meas tran b4_183 FIND V(BIT_4) AT=28550n
.meas tran b5_183 FIND V(BIT_5) AT=28550n
.meas tran b6_183 FIND V(BIT_6) AT=28550n
.meas tran b7_183 FIND V(BIT_7) AT=28550n
.meas tran eoc_184 FIND V(EOC) AT=29750n
.meas tran b0_184 FIND V(BIT_0) AT=29750n
.meas tran b1_184 FIND V(BIT_1) AT=29750n
.meas tran b2_184 FIND V(BIT_2) AT=29750n
.meas tran b3_184 FIND V(BIT_3) AT=29750n
.meas tran b4_184 FIND V(BIT_4) AT=29750n
.meas tran b5_184 FIND V(BIT_5) AT=29750n
.meas tran b6_184 FIND V(BIT_6) AT=29750n
.meas tran b7_184 FIND V(BIT_7) AT=29750n
.meas tran eoc_185 FIND V(EOC) AT=30950n
.meas tran b0_185 FIND V(BIT_0) AT=30950n
.meas tran b1_185 FIND V(BIT_1) AT=30950n
.meas tran b2_185 FIND V(BIT_2) AT=30950n
.meas tran b3_185 FIND V(BIT_3) AT=30950n
.meas tran b4_185 FIND V(BIT_4) AT=30950n
.meas tran b5_185 FIND V(BIT_5) AT=30950n
.meas tran b6_185 FIND V(BIT_6) AT=30950n
.meas tran b7_185 FIND V(BIT_7) AT=30950n
.meas tran eoc_186 FIND V(EOC) AT=32150n
.meas tran b0_186 FIND V(BIT_0) AT=32150n
.meas tran b1_186 FIND V(BIT_1) AT=32150n
.meas tran b2_186 FIND V(BIT_2) AT=32150n
.meas tran b3_186 FIND V(BIT_3) AT=32150n
.meas tran b4_186 FIND V(BIT_4) AT=32150n
.meas tran b5_186 FIND V(BIT_5) AT=32150n
.meas tran b6_186 FIND V(BIT_6) AT=32150n
.meas tran b7_186 FIND V(BIT_7) AT=32150n
.meas tran eoc_187 FIND V(EOC) AT=33350n
.meas tran b0_187 FIND V(BIT_0) AT=33350n
.meas tran b1_187 FIND V(BIT_1) AT=33350n
.meas tran b2_187 FIND V(BIT_2) AT=33350n
.meas tran b3_187 FIND V(BIT_3) AT=33350n
.meas tran b4_187 FIND V(BIT_4) AT=33350n
.meas tran b5_187 FIND V(BIT_5) AT=33350n
.meas tran b6_187 FIND V(BIT_6) AT=33350n
.meas tran b7_187 FIND V(BIT_7) AT=33350n
.meas tran eoc_188 FIND V(EOC) AT=34550n
.meas tran b0_188 FIND V(BIT_0) AT=34550n
.meas tran b1_188 FIND V(BIT_1) AT=34550n
.meas tran b2_188 FIND V(BIT_2) AT=34550n
.meas tran b3_188 FIND V(BIT_3) AT=34550n
.meas tran b4_188 FIND V(BIT_4) AT=34550n
.meas tran b5_188 FIND V(BIT_5) AT=34550n
.meas tran b6_188 FIND V(BIT_6) AT=34550n
.meas tran b7_188 FIND V(BIT_7) AT=34550n
.meas tran eoc_189 FIND V(EOC) AT=35750n
.meas tran b0_189 FIND V(BIT_0) AT=35750n
.meas tran b1_189 FIND V(BIT_1) AT=35750n
.meas tran b2_189 FIND V(BIT_2) AT=35750n
.meas tran b3_189 FIND V(BIT_3) AT=35750n
.meas tran b4_189 FIND V(BIT_4) AT=35750n
.meas tran b5_189 FIND V(BIT_5) AT=35750n
.meas tran b6_189 FIND V(BIT_6) AT=35750n
.meas tran b7_189 FIND V(BIT_7) AT=35750n
.meas tran eoc_190 FIND V(EOC) AT=36950n
.meas tran b0_190 FIND V(BIT_0) AT=36950n
.meas tran b1_190 FIND V(BIT_1) AT=36950n
.meas tran b2_190 FIND V(BIT_2) AT=36950n
.meas tran b3_190 FIND V(BIT_3) AT=36950n
.meas tran b4_190 FIND V(BIT_4) AT=36950n
.meas tran b5_190 FIND V(BIT_5) AT=36950n
.meas tran b6_190 FIND V(BIT_6) AT=36950n
.meas tran b7_190 FIND V(BIT_7) AT=36950n
.meas tran eoc_191 FIND V(EOC) AT=38150n
.meas tran b0_191 FIND V(BIT_0) AT=38150n
.meas tran b1_191 FIND V(BIT_1) AT=38150n
.meas tran b2_191 FIND V(BIT_2) AT=38150n
.meas tran b3_191 FIND V(BIT_3) AT=38150n
.meas tran b4_191 FIND V(BIT_4) AT=38150n
.meas tran b5_191 FIND V(BIT_5) AT=38150n
.meas tran b6_191 FIND V(BIT_6) AT=38150n
.meas tran b7_191 FIND V(BIT_7) AT=38150n
.control
set num_threads=1
run
.endc
.end
