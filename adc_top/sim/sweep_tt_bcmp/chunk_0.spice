* INT-6 Gate-3 sweep chunk 0: codes 0..31 (TT, 3.3 V, 10 MHz)
.include /foss/pdks/gf180mcuD/libs.tech/ngspice/design.ngspice
.lib /foss/pdks/gf180mcuD/libs.tech/ngspice/sm141064.ngspice typical
.lib /foss/pdks/gf180mcuD/libs.tech/ngspice/sm141064.ngspice mimcap_typical
.lib /foss/pdks/gf180mcuD/libs.tech/ngspice/sm141064.ngspice cap_mim
.lib /foss/pdks/gf180mcuD/libs.tech/ngspice/smbb000149.ngspice typical

.include ../adc_top_bcmp_subckt.spice

VVDD VDD 0 3.3
VCLK CLK 0 PULSE(0 3.3 0 1n 1n 49n 100n)
VRST RST_N 0 PULSE(3.3 0 0 1n 1n 120n 1200n)
VVIN vin 0 PWL(0 0.006432 1198n 0.006432 1200n 0.019295 2398n 0.019295 2400n 0.032158 3598n 0.032158 3600n 0.045021 4798n 0.045021 4800n 0.057885 5998n 0.057885 6000n 0.070748 7198n 0.070748 7200n 0.083611 8398n 0.083611 8400n 0.096475 9598n 0.096475 9600n 0.109338 10798n 0.109338 10800n 0.122201 11998n 0.122201 12000n 0.135064 13198n 0.135064 13200n 0.147928 14398n 0.147928 14400n 0.160791 15598n 0.160791 15600n 0.173654 16798n 0.173654 16800n 0.186518 17998n 0.186518 18000n 0.199381 19198n 0.199381 19200n 0.212244 20398n 0.212244 20400n 0.225107 21598n 0.225107 21600n 0.237971 22798n 0.237971 22800n 0.250834 23998n 0.250834 24000n 0.263697 25198n 0.263697 25200n 0.276561 26398n 0.276561 26400n 0.289424 27598n 0.289424 27600n 0.302287 28798n 0.302287 28800n 0.315150 29998n 0.315150 30000n 0.328014 31198n 0.328014 31200n 0.340877 32398n 0.340877 32400n 0.353740 33598n 0.353740 33600n 0.366604 34798n 0.366604 34800n 0.379467 35998n 0.379467 36000n 0.392330 37198n 0.392330 37200n 0.405193 38398n 0.405193)

Xadc VDD 0 vin CLK RST_N BIT_7 BIT_6 BIT_5 BIT_4 BIT_3 BIT_2 BIT_1 BIT_0 EOC adc_top_bcmp

CB7 BIT_7 0 20f
CB6 BIT_6 0 20f
CB5 BIT_5 0 20f
CB4 BIT_4 0 20f
CB3 BIT_3 0 20f
CB2 BIT_2 0 20f
CB1 BIT_1 0 20f
CB0 BIT_0 0 20f
CEOC EOC 0 20f

.tran 0.1n 38.4u
.meas tran eoc_0 FIND V(EOC) AT=950n
.meas tran b0_0 FIND V(BIT_0) AT=950n
.meas tran b1_0 FIND V(BIT_1) AT=950n
.meas tran b2_0 FIND V(BIT_2) AT=950n
.meas tran b3_0 FIND V(BIT_3) AT=950n
.meas tran b4_0 FIND V(BIT_4) AT=950n
.meas tran b5_0 FIND V(BIT_5) AT=950n
.meas tran b6_0 FIND V(BIT_6) AT=950n
.meas tran b7_0 FIND V(BIT_7) AT=950n
.meas tran eoc_1 FIND V(EOC) AT=2150n
.meas tran b0_1 FIND V(BIT_0) AT=2150n
.meas tran b1_1 FIND V(BIT_1) AT=2150n
.meas tran b2_1 FIND V(BIT_2) AT=2150n
.meas tran b3_1 FIND V(BIT_3) AT=2150n
.meas tran b4_1 FIND V(BIT_4) AT=2150n
.meas tran b5_1 FIND V(BIT_5) AT=2150n
.meas tran b6_1 FIND V(BIT_6) AT=2150n
.meas tran b7_1 FIND V(BIT_7) AT=2150n
.meas tran eoc_2 FIND V(EOC) AT=3350n
.meas tran b0_2 FIND V(BIT_0) AT=3350n
.meas tran b1_2 FIND V(BIT_1) AT=3350n
.meas tran b2_2 FIND V(BIT_2) AT=3350n
.meas tran b3_2 FIND V(BIT_3) AT=3350n
.meas tran b4_2 FIND V(BIT_4) AT=3350n
.meas tran b5_2 FIND V(BIT_5) AT=3350n
.meas tran b6_2 FIND V(BIT_6) AT=3350n
.meas tran b7_2 FIND V(BIT_7) AT=3350n
.meas tran eoc_3 FIND V(EOC) AT=4550n
.meas tran b0_3 FIND V(BIT_0) AT=4550n
.meas tran b1_3 FIND V(BIT_1) AT=4550n
.meas tran b2_3 FIND V(BIT_2) AT=4550n
.meas tran b3_3 FIND V(BIT_3) AT=4550n
.meas tran b4_3 FIND V(BIT_4) AT=4550n
.meas tran b5_3 FIND V(BIT_5) AT=4550n
.meas tran b6_3 FIND V(BIT_6) AT=4550n
.meas tran b7_3 FIND V(BIT_7) AT=4550n
.meas tran eoc_4 FIND V(EOC) AT=5750n
.meas tran b0_4 FIND V(BIT_0) AT=5750n
.meas tran b1_4 FIND V(BIT_1) AT=5750n
.meas tran b2_4 FIND V(BIT_2) AT=5750n
.meas tran b3_4 FIND V(BIT_3) AT=5750n
.meas tran b4_4 FIND V(BIT_4) AT=5750n
.meas tran b5_4 FIND V(BIT_5) AT=5750n
.meas tran b6_4 FIND V(BIT_6) AT=5750n
.meas tran b7_4 FIND V(BIT_7) AT=5750n
.meas tran eoc_5 FIND V(EOC) AT=6950n
.meas tran b0_5 FIND V(BIT_0) AT=6950n
.meas tran b1_5 FIND V(BIT_1) AT=6950n
.meas tran b2_5 FIND V(BIT_2) AT=6950n
.meas tran b3_5 FIND V(BIT_3) AT=6950n
.meas tran b4_5 FIND V(BIT_4) AT=6950n
.meas tran b5_5 FIND V(BIT_5) AT=6950n
.meas tran b6_5 FIND V(BIT_6) AT=6950n
.meas tran b7_5 FIND V(BIT_7) AT=6950n
.meas tran eoc_6 FIND V(EOC) AT=8150n
.meas tran b0_6 FIND V(BIT_0) AT=8150n
.meas tran b1_6 FIND V(BIT_1) AT=8150n
.meas tran b2_6 FIND V(BIT_2) AT=8150n
.meas tran b3_6 FIND V(BIT_3) AT=8150n
.meas tran b4_6 FIND V(BIT_4) AT=8150n
.meas tran b5_6 FIND V(BIT_5) AT=8150n
.meas tran b6_6 FIND V(BIT_6) AT=8150n
.meas tran b7_6 FIND V(BIT_7) AT=8150n
.meas tran eoc_7 FIND V(EOC) AT=9350n
.meas tran b0_7 FIND V(BIT_0) AT=9350n
.meas tran b1_7 FIND V(BIT_1) AT=9350n
.meas tran b2_7 FIND V(BIT_2) AT=9350n
.meas tran b3_7 FIND V(BIT_3) AT=9350n
.meas tran b4_7 FIND V(BIT_4) AT=9350n
.meas tran b5_7 FIND V(BIT_5) AT=9350n
.meas tran b6_7 FIND V(BIT_6) AT=9350n
.meas tran b7_7 FIND V(BIT_7) AT=9350n
.meas tran eoc_8 FIND V(EOC) AT=10550n
.meas tran b0_8 FIND V(BIT_0) AT=10550n
.meas tran b1_8 FIND V(BIT_1) AT=10550n
.meas tran b2_8 FIND V(BIT_2) AT=10550n
.meas tran b3_8 FIND V(BIT_3) AT=10550n
.meas tran b4_8 FIND V(BIT_4) AT=10550n
.meas tran b5_8 FIND V(BIT_5) AT=10550n
.meas tran b6_8 FIND V(BIT_6) AT=10550n
.meas tran b7_8 FIND V(BIT_7) AT=10550n
.meas tran eoc_9 FIND V(EOC) AT=11750n
.meas tran b0_9 FIND V(BIT_0) AT=11750n
.meas tran b1_9 FIND V(BIT_1) AT=11750n
.meas tran b2_9 FIND V(BIT_2) AT=11750n
.meas tran b3_9 FIND V(BIT_3) AT=11750n
.meas tran b4_9 FIND V(BIT_4) AT=11750n
.meas tran b5_9 FIND V(BIT_5) AT=11750n
.meas tran b6_9 FIND V(BIT_6) AT=11750n
.meas tran b7_9 FIND V(BIT_7) AT=11750n
.meas tran eoc_10 FIND V(EOC) AT=12950n
.meas tran b0_10 FIND V(BIT_0) AT=12950n
.meas tran b1_10 FIND V(BIT_1) AT=12950n
.meas tran b2_10 FIND V(BIT_2) AT=12950n
.meas tran b3_10 FIND V(BIT_3) AT=12950n
.meas tran b4_10 FIND V(BIT_4) AT=12950n
.meas tran b5_10 FIND V(BIT_5) AT=12950n
.meas tran b6_10 FIND V(BIT_6) AT=12950n
.meas tran b7_10 FIND V(BIT_7) AT=12950n
.meas tran eoc_11 FIND V(EOC) AT=14150n
.meas tran b0_11 FIND V(BIT_0) AT=14150n
.meas tran b1_11 FIND V(BIT_1) AT=14150n
.meas tran b2_11 FIND V(BIT_2) AT=14150n
.meas tran b3_11 FIND V(BIT_3) AT=14150n
.meas tran b4_11 FIND V(BIT_4) AT=14150n
.meas tran b5_11 FIND V(BIT_5) AT=14150n
.meas tran b6_11 FIND V(BIT_6) AT=14150n
.meas tran b7_11 FIND V(BIT_7) AT=14150n
.meas tran eoc_12 FIND V(EOC) AT=15350n
.meas tran b0_12 FIND V(BIT_0) AT=15350n
.meas tran b1_12 FIND V(BIT_1) AT=15350n
.meas tran b2_12 FIND V(BIT_2) AT=15350n
.meas tran b3_12 FIND V(BIT_3) AT=15350n
.meas tran b4_12 FIND V(BIT_4) AT=15350n
.meas tran b5_12 FIND V(BIT_5) AT=15350n
.meas tran b6_12 FIND V(BIT_6) AT=15350n
.meas tran b7_12 FIND V(BIT_7) AT=15350n
.meas tran eoc_13 FIND V(EOC) AT=16550n
.meas tran b0_13 FIND V(BIT_0) AT=16550n
.meas tran b1_13 FIND V(BIT_1) AT=16550n
.meas tran b2_13 FIND V(BIT_2) AT=16550n
.meas tran b3_13 FIND V(BIT_3) AT=16550n
.meas tran b4_13 FIND V(BIT_4) AT=16550n
.meas tran b5_13 FIND V(BIT_5) AT=16550n
.meas tran b6_13 FIND V(BIT_6) AT=16550n
.meas tran b7_13 FIND V(BIT_7) AT=16550n
.meas tran eoc_14 FIND V(EOC) AT=17750n
.meas tran b0_14 FIND V(BIT_0) AT=17750n
.meas tran b1_14 FIND V(BIT_1) AT=17750n
.meas tran b2_14 FIND V(BIT_2) AT=17750n
.meas tran b3_14 FIND V(BIT_3) AT=17750n
.meas tran b4_14 FIND V(BIT_4) AT=17750n
.meas tran b5_14 FIND V(BIT_5) AT=17750n
.meas tran b6_14 FIND V(BIT_6) AT=17750n
.meas tran b7_14 FIND V(BIT_7) AT=17750n
.meas tran eoc_15 FIND V(EOC) AT=18950n
.meas tran b0_15 FIND V(BIT_0) AT=18950n
.meas tran b1_15 FIND V(BIT_1) AT=18950n
.meas tran b2_15 FIND V(BIT_2) AT=18950n
.meas tran b3_15 FIND V(BIT_3) AT=18950n
.meas tran b4_15 FIND V(BIT_4) AT=18950n
.meas tran b5_15 FIND V(BIT_5) AT=18950n
.meas tran b6_15 FIND V(BIT_6) AT=18950n
.meas tran b7_15 FIND V(BIT_7) AT=18950n
.meas tran eoc_16 FIND V(EOC) AT=20150n
.meas tran b0_16 FIND V(BIT_0) AT=20150n
.meas tran b1_16 FIND V(BIT_1) AT=20150n
.meas tran b2_16 FIND V(BIT_2) AT=20150n
.meas tran b3_16 FIND V(BIT_3) AT=20150n
.meas tran b4_16 FIND V(BIT_4) AT=20150n
.meas tran b5_16 FIND V(BIT_5) AT=20150n
.meas tran b6_16 FIND V(BIT_6) AT=20150n
.meas tran b7_16 FIND V(BIT_7) AT=20150n
.meas tran eoc_17 FIND V(EOC) AT=21350n
.meas tran b0_17 FIND V(BIT_0) AT=21350n
.meas tran b1_17 FIND V(BIT_1) AT=21350n
.meas tran b2_17 FIND V(BIT_2) AT=21350n
.meas tran b3_17 FIND V(BIT_3) AT=21350n
.meas tran b4_17 FIND V(BIT_4) AT=21350n
.meas tran b5_17 FIND V(BIT_5) AT=21350n
.meas tran b6_17 FIND V(BIT_6) AT=21350n
.meas tran b7_17 FIND V(BIT_7) AT=21350n
.meas tran eoc_18 FIND V(EOC) AT=22550n
.meas tran b0_18 FIND V(BIT_0) AT=22550n
.meas tran b1_18 FIND V(BIT_1) AT=22550n
.meas tran b2_18 FIND V(BIT_2) AT=22550n
.meas tran b3_18 FIND V(BIT_3) AT=22550n
.meas tran b4_18 FIND V(BIT_4) AT=22550n
.meas tran b5_18 FIND V(BIT_5) AT=22550n
.meas tran b6_18 FIND V(BIT_6) AT=22550n
.meas tran b7_18 FIND V(BIT_7) AT=22550n
.meas tran eoc_19 FIND V(EOC) AT=23750n
.meas tran b0_19 FIND V(BIT_0) AT=23750n
.meas tran b1_19 FIND V(BIT_1) AT=23750n
.meas tran b2_19 FIND V(BIT_2) AT=23750n
.meas tran b3_19 FIND V(BIT_3) AT=23750n
.meas tran b4_19 FIND V(BIT_4) AT=23750n
.meas tran b5_19 FIND V(BIT_5) AT=23750n
.meas tran b6_19 FIND V(BIT_6) AT=23750n
.meas tran b7_19 FIND V(BIT_7) AT=23750n
.meas tran eoc_20 FIND V(EOC) AT=24950n
.meas tran b0_20 FIND V(BIT_0) AT=24950n
.meas tran b1_20 FIND V(BIT_1) AT=24950n
.meas tran b2_20 FIND V(BIT_2) AT=24950n
.meas tran b3_20 FIND V(BIT_3) AT=24950n
.meas tran b4_20 FIND V(BIT_4) AT=24950n
.meas tran b5_20 FIND V(BIT_5) AT=24950n
.meas tran b6_20 FIND V(BIT_6) AT=24950n
.meas tran b7_20 FIND V(BIT_7) AT=24950n
.meas tran eoc_21 FIND V(EOC) AT=26150n
.meas tran b0_21 FIND V(BIT_0) AT=26150n
.meas tran b1_21 FIND V(BIT_1) AT=26150n
.meas tran b2_21 FIND V(BIT_2) AT=26150n
.meas tran b3_21 FIND V(BIT_3) AT=26150n
.meas tran b4_21 FIND V(BIT_4) AT=26150n
.meas tran b5_21 FIND V(BIT_5) AT=26150n
.meas tran b6_21 FIND V(BIT_6) AT=26150n
.meas tran b7_21 FIND V(BIT_7) AT=26150n
.meas tran eoc_22 FIND V(EOC) AT=27350n
.meas tran b0_22 FIND V(BIT_0) AT=27350n
.meas tran b1_22 FIND V(BIT_1) AT=27350n
.meas tran b2_22 FIND V(BIT_2) AT=27350n
.meas tran b3_22 FIND V(BIT_3) AT=27350n
.meas tran b4_22 FIND V(BIT_4) AT=27350n
.meas tran b5_22 FIND V(BIT_5) AT=27350n
.meas tran b6_22 FIND V(BIT_6) AT=27350n
.meas tran b7_22 FIND V(BIT_7) AT=27350n
.meas tran eoc_23 FIND V(EOC) AT=28550n
.meas tran b0_23 FIND V(BIT_0) AT=28550n
.meas tran b1_23 FIND V(BIT_1) AT=28550n
.meas tran b2_23 FIND V(BIT_2) AT=28550n
.meas tran b3_23 FIND V(BIT_3) AT=28550n
.meas tran b4_23 FIND V(BIT_4) AT=28550n
.meas tran b5_23 FIND V(BIT_5) AT=28550n
.meas tran b6_23 FIND V(BIT_6) AT=28550n
.meas tran b7_23 FIND V(BIT_7) AT=28550n
.meas tran eoc_24 FIND V(EOC) AT=29750n
.meas tran b0_24 FIND V(BIT_0) AT=29750n
.meas tran b1_24 FIND V(BIT_1) AT=29750n
.meas tran b2_24 FIND V(BIT_2) AT=29750n
.meas tran b3_24 FIND V(BIT_3) AT=29750n
.meas tran b4_24 FIND V(BIT_4) AT=29750n
.meas tran b5_24 FIND V(BIT_5) AT=29750n
.meas tran b6_24 FIND V(BIT_6) AT=29750n
.meas tran b7_24 FIND V(BIT_7) AT=29750n
.meas tran eoc_25 FIND V(EOC) AT=30950n
.meas tran b0_25 FIND V(BIT_0) AT=30950n
.meas tran b1_25 FIND V(BIT_1) AT=30950n
.meas tran b2_25 FIND V(BIT_2) AT=30950n
.meas tran b3_25 FIND V(BIT_3) AT=30950n
.meas tran b4_25 FIND V(BIT_4) AT=30950n
.meas tran b5_25 FIND V(BIT_5) AT=30950n
.meas tran b6_25 FIND V(BIT_6) AT=30950n
.meas tran b7_25 FIND V(BIT_7) AT=30950n
.meas tran eoc_26 FIND V(EOC) AT=32150n
.meas tran b0_26 FIND V(BIT_0) AT=32150n
.meas tran b1_26 FIND V(BIT_1) AT=32150n
.meas tran b2_26 FIND V(BIT_2) AT=32150n
.meas tran b3_26 FIND V(BIT_3) AT=32150n
.meas tran b4_26 FIND V(BIT_4) AT=32150n
.meas tran b5_26 FIND V(BIT_5) AT=32150n
.meas tran b6_26 FIND V(BIT_6) AT=32150n
.meas tran b7_26 FIND V(BIT_7) AT=32150n
.meas tran eoc_27 FIND V(EOC) AT=33350n
.meas tran b0_27 FIND V(BIT_0) AT=33350n
.meas tran b1_27 FIND V(BIT_1) AT=33350n
.meas tran b2_27 FIND V(BIT_2) AT=33350n
.meas tran b3_27 FIND V(BIT_3) AT=33350n
.meas tran b4_27 FIND V(BIT_4) AT=33350n
.meas tran b5_27 FIND V(BIT_5) AT=33350n
.meas tran b6_27 FIND V(BIT_6) AT=33350n
.meas tran b7_27 FIND V(BIT_7) AT=33350n
.meas tran eoc_28 FIND V(EOC) AT=34550n
.meas tran b0_28 FIND V(BIT_0) AT=34550n
.meas tran b1_28 FIND V(BIT_1) AT=34550n
.meas tran b2_28 FIND V(BIT_2) AT=34550n
.meas tran b3_28 FIND V(BIT_3) AT=34550n
.meas tran b4_28 FIND V(BIT_4) AT=34550n
.meas tran b5_28 FIND V(BIT_5) AT=34550n
.meas tran b6_28 FIND V(BIT_6) AT=34550n
.meas tran b7_28 FIND V(BIT_7) AT=34550n
.meas tran eoc_29 FIND V(EOC) AT=35750n
.meas tran b0_29 FIND V(BIT_0) AT=35750n
.meas tran b1_29 FIND V(BIT_1) AT=35750n
.meas tran b2_29 FIND V(BIT_2) AT=35750n
.meas tran b3_29 FIND V(BIT_3) AT=35750n
.meas tran b4_29 FIND V(BIT_4) AT=35750n
.meas tran b5_29 FIND V(BIT_5) AT=35750n
.meas tran b6_29 FIND V(BIT_6) AT=35750n
.meas tran b7_29 FIND V(BIT_7) AT=35750n
.meas tran eoc_30 FIND V(EOC) AT=36950n
.meas tran b0_30 FIND V(BIT_0) AT=36950n
.meas tran b1_30 FIND V(BIT_1) AT=36950n
.meas tran b2_30 FIND V(BIT_2) AT=36950n
.meas tran b3_30 FIND V(BIT_3) AT=36950n
.meas tran b4_30 FIND V(BIT_4) AT=36950n
.meas tran b5_30 FIND V(BIT_5) AT=36950n
.meas tran b6_30 FIND V(BIT_6) AT=36950n
.meas tran b7_30 FIND V(BIT_7) AT=36950n
.meas tran eoc_31 FIND V(EOC) AT=38150n
.meas tran b0_31 FIND V(BIT_0) AT=38150n
.meas tran b1_31 FIND V(BIT_1) AT=38150n
.meas tran b2_31 FIND V(BIT_2) AT=38150n
.meas tran b3_31 FIND V(BIT_3) AT=38150n
.meas tran b4_31 FIND V(BIT_4) AT=38150n
.meas tran b5_31 FIND V(BIT_5) AT=38150n
.meas tran b6_31 FIND V(BIT_6) AT=38150n
.meas tran b7_31 FIND V(BIT_7) AT=38150n
.control
set num_threads=1
run
.endc
.end
