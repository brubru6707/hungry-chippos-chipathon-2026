* Generated caps-only LVS reference for routed cap_array.
* 255 active caps: DAC_TOP to B0..B7; 69 dummies: GND to GND.
* Native C cards are mandatory for gf180mcu LVS extraction.
.subckt cap_array DAC_TOP B0 B1 B2 B3 B4 B5 B6 B7 GND
C1 B0 DAC_TOP cap_mim_2f0fF W=5e-6 L=5e-6 M=1
C2 B1 DAC_TOP cap_mim_2f0fF W=5e-6 L=5e-6 M=1
C3 B1 DAC_TOP cap_mim_2f0fF W=5e-6 L=5e-6 M=1
C4 B2 DAC_TOP cap_mim_2f0fF W=5e-6 L=5e-6 M=1
C5 B2 DAC_TOP cap_mim_2f0fF W=5e-6 L=5e-6 M=1
C6 B2 DAC_TOP cap_mim_2f0fF W=5e-6 L=5e-6 M=1
C7 B2 DAC_TOP cap_mim_2f0fF W=5e-6 L=5e-6 M=1
C8 B3 DAC_TOP cap_mim_2f0fF W=5e-6 L=5e-6 M=1
C9 B3 DAC_TOP cap_mim_2f0fF W=5e-6 L=5e-6 M=1
C10 B3 DAC_TOP cap_mim_2f0fF W=5e-6 L=5e-6 M=1
C11 B3 DAC_TOP cap_mim_2f0fF W=5e-6 L=5e-6 M=1
C12 B3 DAC_TOP cap_mim_2f0fF W=5e-6 L=5e-6 M=1
C13 B3 DAC_TOP cap_mim_2f0fF W=5e-6 L=5e-6 M=1
C14 B3 DAC_TOP cap_mim_2f0fF W=5e-6 L=5e-6 M=1
C15 B3 DAC_TOP cap_mim_2f0fF W=5e-6 L=5e-6 M=1
C16 B4 DAC_TOP cap_mim_2f0fF W=5e-6 L=5e-6 M=1
C17 B4 DAC_TOP cap_mim_2f0fF W=5e-6 L=5e-6 M=1
C18 B4 DAC_TOP cap_mim_2f0fF W=5e-6 L=5e-6 M=1
C19 B4 DAC_TOP cap_mim_2f0fF W=5e-6 L=5e-6 M=1
C20 B4 DAC_TOP cap_mim_2f0fF W=5e-6 L=5e-6 M=1
C21 B4 DAC_TOP cap_mim_2f0fF W=5e-6 L=5e-6 M=1
C22 B4 DAC_TOP cap_mim_2f0fF W=5e-6 L=5e-6 M=1
C23 B4 DAC_TOP cap_mim_2f0fF W=5e-6 L=5e-6 M=1
C24 B4 DAC_TOP cap_mim_2f0fF W=5e-6 L=5e-6 M=1
C25 B4 DAC_TOP cap_mim_2f0fF W=5e-6 L=5e-6 M=1
C26 B4 DAC_TOP cap_mim_2f0fF W=5e-6 L=5e-6 M=1
C27 B4 DAC_TOP cap_mim_2f0fF W=5e-6 L=5e-6 M=1
C28 B4 DAC_TOP cap_mim_2f0fF W=5e-6 L=5e-6 M=1
C29 B4 DAC_TOP cap_mim_2f0fF W=5e-6 L=5e-6 M=1
C30 B4 DAC_TOP cap_mim_2f0fF W=5e-6 L=5e-6 M=1
C31 B4 DAC_TOP cap_mim_2f0fF W=5e-6 L=5e-6 M=1
C32 B5 DAC_TOP cap_mim_2f0fF W=5e-6 L=5e-6 M=1
C33 B5 DAC_TOP cap_mim_2f0fF W=5e-6 L=5e-6 M=1
C34 B5 DAC_TOP cap_mim_2f0fF W=5e-6 L=5e-6 M=1
C35 B5 DAC_TOP cap_mim_2f0fF W=5e-6 L=5e-6 M=1
C36 B5 DAC_TOP cap_mim_2f0fF W=5e-6 L=5e-6 M=1
C37 B5 DAC_TOP cap_mim_2f0fF W=5e-6 L=5e-6 M=1
C38 B5 DAC_TOP cap_mim_2f0fF W=5e-6 L=5e-6 M=1
C39 B5 DAC_TOP cap_mim_2f0fF W=5e-6 L=5e-6 M=1
C40 B5 DAC_TOP cap_mim_2f0fF W=5e-6 L=5e-6 M=1
C41 B5 DAC_TOP cap_mim_2f0fF W=5e-6 L=5e-6 M=1
C42 B5 DAC_TOP cap_mim_2f0fF W=5e-6 L=5e-6 M=1
C43 B5 DAC_TOP cap_mim_2f0fF W=5e-6 L=5e-6 M=1
C44 B5 DAC_TOP cap_mim_2f0fF W=5e-6 L=5e-6 M=1
C45 B5 DAC_TOP cap_mim_2f0fF W=5e-6 L=5e-6 M=1
C46 B5 DAC_TOP cap_mim_2f0fF W=5e-6 L=5e-6 M=1
C47 B5 DAC_TOP cap_mim_2f0fF W=5e-6 L=5e-6 M=1
C48 B5 DAC_TOP cap_mim_2f0fF W=5e-6 L=5e-6 M=1
C49 B5 DAC_TOP cap_mim_2f0fF W=5e-6 L=5e-6 M=1
C50 B5 DAC_TOP cap_mim_2f0fF W=5e-6 L=5e-6 M=1
C51 B5 DAC_TOP cap_mim_2f0fF W=5e-6 L=5e-6 M=1
C52 B5 DAC_TOP cap_mim_2f0fF W=5e-6 L=5e-6 M=1
C53 B5 DAC_TOP cap_mim_2f0fF W=5e-6 L=5e-6 M=1
C54 B5 DAC_TOP cap_mim_2f0fF W=5e-6 L=5e-6 M=1
C55 B5 DAC_TOP cap_mim_2f0fF W=5e-6 L=5e-6 M=1
C56 B5 DAC_TOP cap_mim_2f0fF W=5e-6 L=5e-6 M=1
C57 B5 DAC_TOP cap_mim_2f0fF W=5e-6 L=5e-6 M=1
C58 B5 DAC_TOP cap_mim_2f0fF W=5e-6 L=5e-6 M=1
C59 B5 DAC_TOP cap_mim_2f0fF W=5e-6 L=5e-6 M=1
C60 B5 DAC_TOP cap_mim_2f0fF W=5e-6 L=5e-6 M=1
C61 B5 DAC_TOP cap_mim_2f0fF W=5e-6 L=5e-6 M=1
C62 B5 DAC_TOP cap_mim_2f0fF W=5e-6 L=5e-6 M=1
C63 B5 DAC_TOP cap_mim_2f0fF W=5e-6 L=5e-6 M=1
C64 B6 DAC_TOP cap_mim_2f0fF W=5e-6 L=5e-6 M=1
C65 B6 DAC_TOP cap_mim_2f0fF W=5e-6 L=5e-6 M=1
C66 B6 DAC_TOP cap_mim_2f0fF W=5e-6 L=5e-6 M=1
C67 B6 DAC_TOP cap_mim_2f0fF W=5e-6 L=5e-6 M=1
C68 B6 DAC_TOP cap_mim_2f0fF W=5e-6 L=5e-6 M=1
C69 B6 DAC_TOP cap_mim_2f0fF W=5e-6 L=5e-6 M=1
C70 B6 DAC_TOP cap_mim_2f0fF W=5e-6 L=5e-6 M=1
C71 B6 DAC_TOP cap_mim_2f0fF W=5e-6 L=5e-6 M=1
C72 B6 DAC_TOP cap_mim_2f0fF W=5e-6 L=5e-6 M=1
C73 B6 DAC_TOP cap_mim_2f0fF W=5e-6 L=5e-6 M=1
C74 B6 DAC_TOP cap_mim_2f0fF W=5e-6 L=5e-6 M=1
C75 B6 DAC_TOP cap_mim_2f0fF W=5e-6 L=5e-6 M=1
C76 B6 DAC_TOP cap_mim_2f0fF W=5e-6 L=5e-6 M=1
C77 B6 DAC_TOP cap_mim_2f0fF W=5e-6 L=5e-6 M=1
C78 B6 DAC_TOP cap_mim_2f0fF W=5e-6 L=5e-6 M=1
C79 B6 DAC_TOP cap_mim_2f0fF W=5e-6 L=5e-6 M=1
C80 B6 DAC_TOP cap_mim_2f0fF W=5e-6 L=5e-6 M=1
C81 B6 DAC_TOP cap_mim_2f0fF W=5e-6 L=5e-6 M=1
C82 B6 DAC_TOP cap_mim_2f0fF W=5e-6 L=5e-6 M=1
C83 B6 DAC_TOP cap_mim_2f0fF W=5e-6 L=5e-6 M=1
C84 B6 DAC_TOP cap_mim_2f0fF W=5e-6 L=5e-6 M=1
C85 B6 DAC_TOP cap_mim_2f0fF W=5e-6 L=5e-6 M=1
C86 B6 DAC_TOP cap_mim_2f0fF W=5e-6 L=5e-6 M=1
C87 B6 DAC_TOP cap_mim_2f0fF W=5e-6 L=5e-6 M=1
C88 B6 DAC_TOP cap_mim_2f0fF W=5e-6 L=5e-6 M=1
C89 B6 DAC_TOP cap_mim_2f0fF W=5e-6 L=5e-6 M=1
C90 B6 DAC_TOP cap_mim_2f0fF W=5e-6 L=5e-6 M=1
C91 B6 DAC_TOP cap_mim_2f0fF W=5e-6 L=5e-6 M=1
C92 B6 DAC_TOP cap_mim_2f0fF W=5e-6 L=5e-6 M=1
C93 B6 DAC_TOP cap_mim_2f0fF W=5e-6 L=5e-6 M=1
C94 B6 DAC_TOP cap_mim_2f0fF W=5e-6 L=5e-6 M=1
C95 B6 DAC_TOP cap_mim_2f0fF W=5e-6 L=5e-6 M=1
C96 B6 DAC_TOP cap_mim_2f0fF W=5e-6 L=5e-6 M=1
C97 B6 DAC_TOP cap_mim_2f0fF W=5e-6 L=5e-6 M=1
C98 B6 DAC_TOP cap_mim_2f0fF W=5e-6 L=5e-6 M=1
C99 B6 DAC_TOP cap_mim_2f0fF W=5e-6 L=5e-6 M=1
C100 B6 DAC_TOP cap_mim_2f0fF W=5e-6 L=5e-6 M=1
C101 B6 DAC_TOP cap_mim_2f0fF W=5e-6 L=5e-6 M=1
C102 B6 DAC_TOP cap_mim_2f0fF W=5e-6 L=5e-6 M=1
C103 B6 DAC_TOP cap_mim_2f0fF W=5e-6 L=5e-6 M=1
C104 B6 DAC_TOP cap_mim_2f0fF W=5e-6 L=5e-6 M=1
C105 B6 DAC_TOP cap_mim_2f0fF W=5e-6 L=5e-6 M=1
C106 B6 DAC_TOP cap_mim_2f0fF W=5e-6 L=5e-6 M=1
C107 B6 DAC_TOP cap_mim_2f0fF W=5e-6 L=5e-6 M=1
C108 B6 DAC_TOP cap_mim_2f0fF W=5e-6 L=5e-6 M=1
C109 B6 DAC_TOP cap_mim_2f0fF W=5e-6 L=5e-6 M=1
C110 B6 DAC_TOP cap_mim_2f0fF W=5e-6 L=5e-6 M=1
C111 B6 DAC_TOP cap_mim_2f0fF W=5e-6 L=5e-6 M=1
C112 B6 DAC_TOP cap_mim_2f0fF W=5e-6 L=5e-6 M=1
C113 B6 DAC_TOP cap_mim_2f0fF W=5e-6 L=5e-6 M=1
C114 B6 DAC_TOP cap_mim_2f0fF W=5e-6 L=5e-6 M=1
C115 B6 DAC_TOP cap_mim_2f0fF W=5e-6 L=5e-6 M=1
C116 B6 DAC_TOP cap_mim_2f0fF W=5e-6 L=5e-6 M=1
C117 B6 DAC_TOP cap_mim_2f0fF W=5e-6 L=5e-6 M=1
C118 B6 DAC_TOP cap_mim_2f0fF W=5e-6 L=5e-6 M=1
C119 B6 DAC_TOP cap_mim_2f0fF W=5e-6 L=5e-6 M=1
C120 B6 DAC_TOP cap_mim_2f0fF W=5e-6 L=5e-6 M=1
C121 B6 DAC_TOP cap_mim_2f0fF W=5e-6 L=5e-6 M=1
C122 B6 DAC_TOP cap_mim_2f0fF W=5e-6 L=5e-6 M=1
C123 B6 DAC_TOP cap_mim_2f0fF W=5e-6 L=5e-6 M=1
C124 B6 DAC_TOP cap_mim_2f0fF W=5e-6 L=5e-6 M=1
C125 B6 DAC_TOP cap_mim_2f0fF W=5e-6 L=5e-6 M=1
C126 B6 DAC_TOP cap_mim_2f0fF W=5e-6 L=5e-6 M=1
C127 B6 DAC_TOP cap_mim_2f0fF W=5e-6 L=5e-6 M=1
C128 B7 DAC_TOP cap_mim_2f0fF W=5e-6 L=5e-6 M=1
C129 B7 DAC_TOP cap_mim_2f0fF W=5e-6 L=5e-6 M=1
C130 B7 DAC_TOP cap_mim_2f0fF W=5e-6 L=5e-6 M=1
C131 B7 DAC_TOP cap_mim_2f0fF W=5e-6 L=5e-6 M=1
C132 B7 DAC_TOP cap_mim_2f0fF W=5e-6 L=5e-6 M=1
C133 B7 DAC_TOP cap_mim_2f0fF W=5e-6 L=5e-6 M=1
C134 B7 DAC_TOP cap_mim_2f0fF W=5e-6 L=5e-6 M=1
C135 B7 DAC_TOP cap_mim_2f0fF W=5e-6 L=5e-6 M=1
C136 B7 DAC_TOP cap_mim_2f0fF W=5e-6 L=5e-6 M=1
C137 B7 DAC_TOP cap_mim_2f0fF W=5e-6 L=5e-6 M=1
C138 B7 DAC_TOP cap_mim_2f0fF W=5e-6 L=5e-6 M=1
C139 B7 DAC_TOP cap_mim_2f0fF W=5e-6 L=5e-6 M=1
C140 B7 DAC_TOP cap_mim_2f0fF W=5e-6 L=5e-6 M=1
C141 B7 DAC_TOP cap_mim_2f0fF W=5e-6 L=5e-6 M=1
C142 B7 DAC_TOP cap_mim_2f0fF W=5e-6 L=5e-6 M=1
C143 B7 DAC_TOP cap_mim_2f0fF W=5e-6 L=5e-6 M=1
C144 B7 DAC_TOP cap_mim_2f0fF W=5e-6 L=5e-6 M=1
C145 B7 DAC_TOP cap_mim_2f0fF W=5e-6 L=5e-6 M=1
C146 B7 DAC_TOP cap_mim_2f0fF W=5e-6 L=5e-6 M=1
C147 B7 DAC_TOP cap_mim_2f0fF W=5e-6 L=5e-6 M=1
C148 B7 DAC_TOP cap_mim_2f0fF W=5e-6 L=5e-6 M=1
C149 B7 DAC_TOP cap_mim_2f0fF W=5e-6 L=5e-6 M=1
C150 B7 DAC_TOP cap_mim_2f0fF W=5e-6 L=5e-6 M=1
C151 B7 DAC_TOP cap_mim_2f0fF W=5e-6 L=5e-6 M=1
C152 B7 DAC_TOP cap_mim_2f0fF W=5e-6 L=5e-6 M=1
C153 B7 DAC_TOP cap_mim_2f0fF W=5e-6 L=5e-6 M=1
C154 B7 DAC_TOP cap_mim_2f0fF W=5e-6 L=5e-6 M=1
C155 B7 DAC_TOP cap_mim_2f0fF W=5e-6 L=5e-6 M=1
C156 B7 DAC_TOP cap_mim_2f0fF W=5e-6 L=5e-6 M=1
C157 B7 DAC_TOP cap_mim_2f0fF W=5e-6 L=5e-6 M=1
C158 B7 DAC_TOP cap_mim_2f0fF W=5e-6 L=5e-6 M=1
C159 B7 DAC_TOP cap_mim_2f0fF W=5e-6 L=5e-6 M=1
C160 B7 DAC_TOP cap_mim_2f0fF W=5e-6 L=5e-6 M=1
C161 B7 DAC_TOP cap_mim_2f0fF W=5e-6 L=5e-6 M=1
C162 B7 DAC_TOP cap_mim_2f0fF W=5e-6 L=5e-6 M=1
C163 B7 DAC_TOP cap_mim_2f0fF W=5e-6 L=5e-6 M=1
C164 B7 DAC_TOP cap_mim_2f0fF W=5e-6 L=5e-6 M=1
C165 B7 DAC_TOP cap_mim_2f0fF W=5e-6 L=5e-6 M=1
C166 B7 DAC_TOP cap_mim_2f0fF W=5e-6 L=5e-6 M=1
C167 B7 DAC_TOP cap_mim_2f0fF W=5e-6 L=5e-6 M=1
C168 B7 DAC_TOP cap_mim_2f0fF W=5e-6 L=5e-6 M=1
C169 B7 DAC_TOP cap_mim_2f0fF W=5e-6 L=5e-6 M=1
C170 B7 DAC_TOP cap_mim_2f0fF W=5e-6 L=5e-6 M=1
C171 B7 DAC_TOP cap_mim_2f0fF W=5e-6 L=5e-6 M=1
C172 B7 DAC_TOP cap_mim_2f0fF W=5e-6 L=5e-6 M=1
C173 B7 DAC_TOP cap_mim_2f0fF W=5e-6 L=5e-6 M=1
C174 B7 DAC_TOP cap_mim_2f0fF W=5e-6 L=5e-6 M=1
C175 B7 DAC_TOP cap_mim_2f0fF W=5e-6 L=5e-6 M=1
C176 B7 DAC_TOP cap_mim_2f0fF W=5e-6 L=5e-6 M=1
C177 B7 DAC_TOP cap_mim_2f0fF W=5e-6 L=5e-6 M=1
C178 B7 DAC_TOP cap_mim_2f0fF W=5e-6 L=5e-6 M=1
C179 B7 DAC_TOP cap_mim_2f0fF W=5e-6 L=5e-6 M=1
C180 B7 DAC_TOP cap_mim_2f0fF W=5e-6 L=5e-6 M=1
C181 B7 DAC_TOP cap_mim_2f0fF W=5e-6 L=5e-6 M=1
C182 B7 DAC_TOP cap_mim_2f0fF W=5e-6 L=5e-6 M=1
C183 B7 DAC_TOP cap_mim_2f0fF W=5e-6 L=5e-6 M=1
C184 B7 DAC_TOP cap_mim_2f0fF W=5e-6 L=5e-6 M=1
C185 B7 DAC_TOP cap_mim_2f0fF W=5e-6 L=5e-6 M=1
C186 B7 DAC_TOP cap_mim_2f0fF W=5e-6 L=5e-6 M=1
C187 B7 DAC_TOP cap_mim_2f0fF W=5e-6 L=5e-6 M=1
C188 B7 DAC_TOP cap_mim_2f0fF W=5e-6 L=5e-6 M=1
C189 B7 DAC_TOP cap_mim_2f0fF W=5e-6 L=5e-6 M=1
C190 B7 DAC_TOP cap_mim_2f0fF W=5e-6 L=5e-6 M=1
C191 B7 DAC_TOP cap_mim_2f0fF W=5e-6 L=5e-6 M=1
C192 B7 DAC_TOP cap_mim_2f0fF W=5e-6 L=5e-6 M=1
C193 B7 DAC_TOP cap_mim_2f0fF W=5e-6 L=5e-6 M=1
C194 B7 DAC_TOP cap_mim_2f0fF W=5e-6 L=5e-6 M=1
C195 B7 DAC_TOP cap_mim_2f0fF W=5e-6 L=5e-6 M=1
C196 B7 DAC_TOP cap_mim_2f0fF W=5e-6 L=5e-6 M=1
C197 B7 DAC_TOP cap_mim_2f0fF W=5e-6 L=5e-6 M=1
C198 B7 DAC_TOP cap_mim_2f0fF W=5e-6 L=5e-6 M=1
C199 B7 DAC_TOP cap_mim_2f0fF W=5e-6 L=5e-6 M=1
C200 B7 DAC_TOP cap_mim_2f0fF W=5e-6 L=5e-6 M=1
C201 B7 DAC_TOP cap_mim_2f0fF W=5e-6 L=5e-6 M=1
C202 B7 DAC_TOP cap_mim_2f0fF W=5e-6 L=5e-6 M=1
C203 B7 DAC_TOP cap_mim_2f0fF W=5e-6 L=5e-6 M=1
C204 B7 DAC_TOP cap_mim_2f0fF W=5e-6 L=5e-6 M=1
C205 B7 DAC_TOP cap_mim_2f0fF W=5e-6 L=5e-6 M=1
C206 B7 DAC_TOP cap_mim_2f0fF W=5e-6 L=5e-6 M=1
C207 B7 DAC_TOP cap_mim_2f0fF W=5e-6 L=5e-6 M=1
C208 B7 DAC_TOP cap_mim_2f0fF W=5e-6 L=5e-6 M=1
C209 B7 DAC_TOP cap_mim_2f0fF W=5e-6 L=5e-6 M=1
C210 B7 DAC_TOP cap_mim_2f0fF W=5e-6 L=5e-6 M=1
C211 B7 DAC_TOP cap_mim_2f0fF W=5e-6 L=5e-6 M=1
C212 B7 DAC_TOP cap_mim_2f0fF W=5e-6 L=5e-6 M=1
C213 B7 DAC_TOP cap_mim_2f0fF W=5e-6 L=5e-6 M=1
C214 B7 DAC_TOP cap_mim_2f0fF W=5e-6 L=5e-6 M=1
C215 B7 DAC_TOP cap_mim_2f0fF W=5e-6 L=5e-6 M=1
C216 B7 DAC_TOP cap_mim_2f0fF W=5e-6 L=5e-6 M=1
C217 B7 DAC_TOP cap_mim_2f0fF W=5e-6 L=5e-6 M=1
C218 B7 DAC_TOP cap_mim_2f0fF W=5e-6 L=5e-6 M=1
C219 B7 DAC_TOP cap_mim_2f0fF W=5e-6 L=5e-6 M=1
C220 B7 DAC_TOP cap_mim_2f0fF W=5e-6 L=5e-6 M=1
C221 B7 DAC_TOP cap_mim_2f0fF W=5e-6 L=5e-6 M=1
C222 B7 DAC_TOP cap_mim_2f0fF W=5e-6 L=5e-6 M=1
C223 B7 DAC_TOP cap_mim_2f0fF W=5e-6 L=5e-6 M=1
C224 B7 DAC_TOP cap_mim_2f0fF W=5e-6 L=5e-6 M=1
C225 B7 DAC_TOP cap_mim_2f0fF W=5e-6 L=5e-6 M=1
C226 B7 DAC_TOP cap_mim_2f0fF W=5e-6 L=5e-6 M=1
C227 B7 DAC_TOP cap_mim_2f0fF W=5e-6 L=5e-6 M=1
C228 B7 DAC_TOP cap_mim_2f0fF W=5e-6 L=5e-6 M=1
C229 B7 DAC_TOP cap_mim_2f0fF W=5e-6 L=5e-6 M=1
C230 B7 DAC_TOP cap_mim_2f0fF W=5e-6 L=5e-6 M=1
C231 B7 DAC_TOP cap_mim_2f0fF W=5e-6 L=5e-6 M=1
C232 B7 DAC_TOP cap_mim_2f0fF W=5e-6 L=5e-6 M=1
C233 B7 DAC_TOP cap_mim_2f0fF W=5e-6 L=5e-6 M=1
C234 B7 DAC_TOP cap_mim_2f0fF W=5e-6 L=5e-6 M=1
C235 B7 DAC_TOP cap_mim_2f0fF W=5e-6 L=5e-6 M=1
C236 B7 DAC_TOP cap_mim_2f0fF W=5e-6 L=5e-6 M=1
C237 B7 DAC_TOP cap_mim_2f0fF W=5e-6 L=5e-6 M=1
C238 B7 DAC_TOP cap_mim_2f0fF W=5e-6 L=5e-6 M=1
C239 B7 DAC_TOP cap_mim_2f0fF W=5e-6 L=5e-6 M=1
C240 B7 DAC_TOP cap_mim_2f0fF W=5e-6 L=5e-6 M=1
C241 B7 DAC_TOP cap_mim_2f0fF W=5e-6 L=5e-6 M=1
C242 B7 DAC_TOP cap_mim_2f0fF W=5e-6 L=5e-6 M=1
C243 B7 DAC_TOP cap_mim_2f0fF W=5e-6 L=5e-6 M=1
C244 B7 DAC_TOP cap_mim_2f0fF W=5e-6 L=5e-6 M=1
C245 B7 DAC_TOP cap_mim_2f0fF W=5e-6 L=5e-6 M=1
C246 B7 DAC_TOP cap_mim_2f0fF W=5e-6 L=5e-6 M=1
C247 B7 DAC_TOP cap_mim_2f0fF W=5e-6 L=5e-6 M=1
C248 B7 DAC_TOP cap_mim_2f0fF W=5e-6 L=5e-6 M=1
C249 B7 DAC_TOP cap_mim_2f0fF W=5e-6 L=5e-6 M=1
C250 B7 DAC_TOP cap_mim_2f0fF W=5e-6 L=5e-6 M=1
C251 B7 DAC_TOP cap_mim_2f0fF W=5e-6 L=5e-6 M=1
C252 B7 DAC_TOP cap_mim_2f0fF W=5e-6 L=5e-6 M=1
C253 B7 DAC_TOP cap_mim_2f0fF W=5e-6 L=5e-6 M=1
C254 B7 DAC_TOP cap_mim_2f0fF W=5e-6 L=5e-6 M=1
C255 B7 DAC_TOP cap_mim_2f0fF W=5e-6 L=5e-6 M=1
C256 GND GND cap_mim_2f0fF W=5e-6 L=5e-6 M=1
C257 GND GND cap_mim_2f0fF W=5e-6 L=5e-6 M=1
C258 GND GND cap_mim_2f0fF W=5e-6 L=5e-6 M=1
C259 GND GND cap_mim_2f0fF W=5e-6 L=5e-6 M=1
C260 GND GND cap_mim_2f0fF W=5e-6 L=5e-6 M=1
C261 GND GND cap_mim_2f0fF W=5e-6 L=5e-6 M=1
C262 GND GND cap_mim_2f0fF W=5e-6 L=5e-6 M=1
C263 GND GND cap_mim_2f0fF W=5e-6 L=5e-6 M=1
C264 GND GND cap_mim_2f0fF W=5e-6 L=5e-6 M=1
C265 GND GND cap_mim_2f0fF W=5e-6 L=5e-6 M=1
C266 GND GND cap_mim_2f0fF W=5e-6 L=5e-6 M=1
C267 GND GND cap_mim_2f0fF W=5e-6 L=5e-6 M=1
C268 GND GND cap_mim_2f0fF W=5e-6 L=5e-6 M=1
C269 GND GND cap_mim_2f0fF W=5e-6 L=5e-6 M=1
C270 GND GND cap_mim_2f0fF W=5e-6 L=5e-6 M=1
C271 GND GND cap_mim_2f0fF W=5e-6 L=5e-6 M=1
C272 GND GND cap_mim_2f0fF W=5e-6 L=5e-6 M=1
C273 GND GND cap_mim_2f0fF W=5e-6 L=5e-6 M=1
C274 GND GND cap_mim_2f0fF W=5e-6 L=5e-6 M=1
C275 GND GND cap_mim_2f0fF W=5e-6 L=5e-6 M=1
C276 GND GND cap_mim_2f0fF W=5e-6 L=5e-6 M=1
C277 GND GND cap_mim_2f0fF W=5e-6 L=5e-6 M=1
C278 GND GND cap_mim_2f0fF W=5e-6 L=5e-6 M=1
C279 GND GND cap_mim_2f0fF W=5e-6 L=5e-6 M=1
C280 GND GND cap_mim_2f0fF W=5e-6 L=5e-6 M=1
C281 GND GND cap_mim_2f0fF W=5e-6 L=5e-6 M=1
C282 GND GND cap_mim_2f0fF W=5e-6 L=5e-6 M=1
C283 GND GND cap_mim_2f0fF W=5e-6 L=5e-6 M=1
C284 GND GND cap_mim_2f0fF W=5e-6 L=5e-6 M=1
C285 GND GND cap_mim_2f0fF W=5e-6 L=5e-6 M=1
C286 GND GND cap_mim_2f0fF W=5e-6 L=5e-6 M=1
C287 GND GND cap_mim_2f0fF W=5e-6 L=5e-6 M=1
C288 GND GND cap_mim_2f0fF W=5e-6 L=5e-6 M=1
C289 GND GND cap_mim_2f0fF W=5e-6 L=5e-6 M=1
C290 GND GND cap_mim_2f0fF W=5e-6 L=5e-6 M=1
C291 GND GND cap_mim_2f0fF W=5e-6 L=5e-6 M=1
C292 GND GND cap_mim_2f0fF W=5e-6 L=5e-6 M=1
C293 GND GND cap_mim_2f0fF W=5e-6 L=5e-6 M=1
C294 GND GND cap_mim_2f0fF W=5e-6 L=5e-6 M=1
C295 GND GND cap_mim_2f0fF W=5e-6 L=5e-6 M=1
C296 GND GND cap_mim_2f0fF W=5e-6 L=5e-6 M=1
C297 GND GND cap_mim_2f0fF W=5e-6 L=5e-6 M=1
C298 GND GND cap_mim_2f0fF W=5e-6 L=5e-6 M=1
C299 GND GND cap_mim_2f0fF W=5e-6 L=5e-6 M=1
C300 GND GND cap_mim_2f0fF W=5e-6 L=5e-6 M=1
C301 GND GND cap_mim_2f0fF W=5e-6 L=5e-6 M=1
C302 GND GND cap_mim_2f0fF W=5e-6 L=5e-6 M=1
C303 GND GND cap_mim_2f0fF W=5e-6 L=5e-6 M=1
C304 GND GND cap_mim_2f0fF W=5e-6 L=5e-6 M=1
C305 GND GND cap_mim_2f0fF W=5e-6 L=5e-6 M=1
C306 GND GND cap_mim_2f0fF W=5e-6 L=5e-6 M=1
C307 GND GND cap_mim_2f0fF W=5e-6 L=5e-6 M=1
C308 GND GND cap_mim_2f0fF W=5e-6 L=5e-6 M=1
C309 GND GND cap_mim_2f0fF W=5e-6 L=5e-6 M=1
C310 GND GND cap_mim_2f0fF W=5e-6 L=5e-6 M=1
C311 GND GND cap_mim_2f0fF W=5e-6 L=5e-6 M=1
C312 GND GND cap_mim_2f0fF W=5e-6 L=5e-6 M=1
C313 GND GND cap_mim_2f0fF W=5e-6 L=5e-6 M=1
C314 GND GND cap_mim_2f0fF W=5e-6 L=5e-6 M=1
C315 GND GND cap_mim_2f0fF W=5e-6 L=5e-6 M=1
C316 GND GND cap_mim_2f0fF W=5e-6 L=5e-6 M=1
C317 GND GND cap_mim_2f0fF W=5e-6 L=5e-6 M=1
C318 GND GND cap_mim_2f0fF W=5e-6 L=5e-6 M=1
C319 GND GND cap_mim_2f0fF W=5e-6 L=5e-6 M=1
C320 GND GND cap_mim_2f0fF W=5e-6 L=5e-6 M=1
C321 GND GND cap_mim_2f0fF W=5e-6 L=5e-6 M=1
C322 GND GND cap_mim_2f0fF W=5e-6 L=5e-6 M=1
C323 GND GND cap_mim_2f0fF W=5e-6 L=5e-6 M=1
C324 GND GND cap_mim_2f0fF W=5e-6 L=5e-6 M=1
.ends cap_array
