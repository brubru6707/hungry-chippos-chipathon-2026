* Extracted by KLayout with GF180MCU LVS runset on : 06/08/2026 22:48

.SUBCKT comparator_2stage VDD CKL CK VIN1 VIN2 VOUT1 VOUT2 VSS
X$1 VDD VIN1 VIN2 CK \$3 \$2 VSS preamp_dyn
X$2 CKL \$3 \$2 VOUT2 VOUT1 VDD VSS strongarm_2
.ENDS comparator_2stage

.SUBCKT strongarm_2 CK VIN1 VIN2 VOUT2 VOUT1 VDD VSS
M$1 VDD CK \$4 VDD pfet_03v3 L=0.28U W=5U AS=3.25P AD=3.25P PS=11.3U PD=11.3U
M$2 VDD CK \$5 VDD pfet_03v3 L=0.28U W=5U AS=3.25P AD=3.25P PS=11.3U PD=11.3U
M$3 VDD CK VOUT2 VDD pfet_03v3 L=0.28U W=5U AS=3.25P AD=3.25P PS=11.3U PD=11.3U
M$4 VDD CK VOUT1 VDD pfet_03v3 L=0.28U W=5U AS=3.25P AD=3.25P PS=11.3U PD=11.3U
M$5 VDD VOUT1 VOUT2 VDD pfet_03v3 L=0.28U W=0.42U AS=0.2822P AD=0.2822P
+ PS=2.18U PD=2.18U
M$6 VDD VOUT2 VOUT1 VDD pfet_03v3 L=0.28U W=0.42U AS=0.2822P AD=0.2822P
+ PS=2.18U PD=2.18U
M$7 VSS CK \$3 VSS nfet_03v3 L=0.28U W=2U AS=1.22P AD=1.22P PS=5.22U PD=5.22U
M$8 \$4 VOUT2 VOUT1 VSS nfet_03v3 L=0.28U W=2U AS=1.22P AD=1.22P PS=5.22U
+ PD=5.22U
M$9 \$5 VOUT1 VOUT2 VSS nfet_03v3 L=0.28U W=2U AS=1.22P AD=1.22P PS=5.22U
+ PD=5.22U
M$10 \$3 VIN2 \$5 VSS nfet_03v3 L=1U W=8U AS=2.78P AD=2.78P PS=12.78U PD=12.78U
M$14 \$3 VIN1 \$4 VSS nfet_03v3 L=1U W=8U AS=2.78P AD=2.78P PS=12.78U PD=12.78U
.ENDS strongarm_2

.SUBCKT preamp_dyn VDD VIN1 VIN2 CK DIP1 DIP2 VSS
M$1 DIP1 VIN1 \$8 VSS nfet_03v3 L=1U W=64U AS=18.04P AD=18.04P PS=77.02U
+ PD=77.02U
M$17 DIP2 VIN2 \$8 VSS nfet_03v3 L=1U W=64U AS=18.04P AD=18.04P PS=77.02U
+ PD=77.02U
M$33 VDD CK DIP2 VDD pfet_03v3 L=0.3U W=3U AS=1.95P AD=1.95P PS=7.3U PD=7.3U
M$34 VDD CK DIP1 VDD pfet_03v3 L=0.3U W=3U AS=1.95P AD=1.95P PS=7.3U PD=7.3U
M$35 VSS CK \$8 VSS nfet_03v3 L=1U W=1U AS=0.61P AD=0.61P PS=3.22U PD=3.22U
.ENDS preamp_dyn
