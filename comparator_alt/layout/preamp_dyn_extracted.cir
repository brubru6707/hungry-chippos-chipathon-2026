* Extracted by KLayout with GF180MCU LVS runset on : 06/08/2026 19:37

.SUBCKT preamp_dyn VDD VIN1 VIN2 CK DIP1 DIP2 VSS
M$1 DIP1 VIN1 \$8 VSS nfet_03v3 L=1U W=64U AS=18.04P AD=18.04P PS=77.02U
+ PD=77.02U
M$17 DIP2 VIN2 \$8 VSS nfet_03v3 L=1U W=64U AS=18.04P AD=18.04P PS=77.02U
+ PD=77.02U
M$33 VDD CK DIP2 VDD pfet_03v3 L=0.3U W=3U AS=1.95P AD=1.95P PS=7.3U PD=7.3U
M$34 VDD CK DIP1 VDD pfet_03v3 L=0.3U W=3U AS=1.95P AD=1.95P PS=7.3U PD=7.3U
M$35 VSS CK \$8 VSS nfet_03v3 L=1U W=1U AS=0.61P AD=0.61P PS=3.22U PD=3.22U
.ENDS preamp_dyn
